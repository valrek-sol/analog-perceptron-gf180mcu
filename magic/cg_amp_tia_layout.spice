* NGSPICE file created from cg_amp_tia.ext - technology: gf180mcuD

.subckt ppolyf_u_1k_E2RDXR a_n512_n1144# a_n300_810# a_n300_n932#
X0 a_n300_810# a_n300_n932# a_n512_n1144# ppolyf_u_1k r_width=3u r_length=8.1u
.ends

.subckt nfet_03v3_LEXRL4 a_n276_n662# a_50_n524# a_n50_n568# a_n138_n524#
X0 a_50_n524# a_n50_n568# a_n138_n524# a_n276_n662# nfet_03v3 ad=2.2p pd=10.88u as=2.2p ps=10.88u w=5u l=0.5u
.ends

.subckt cg_amp_tia V_ref V_out V_bias I_in VSS
XXR1 VSS V_ref V_out ppolyf_u_1k_E2RDXR
XM1 VSS V_out V_bias I_in nfet_03v3_LEXRL4
.ends
