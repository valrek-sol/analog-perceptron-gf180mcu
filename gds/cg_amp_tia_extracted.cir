* Extracted by KLayout with GF180MCU LVS runset on : 31/10/2026 13:35

.SUBCKT cg_amp_tia V_out V_ref I_in VSS
R$1 V_out V_ref VSS 2700 ppolyf_u_1k L=8.1U W=3U
M$2 V_out V_ref I_in VSS nfet_03v3 L=0.5U W=5U AS=2.175P AD=2.175P PS=9.24U
+ PD=9.24U
.ENDS cg_amp_tia
