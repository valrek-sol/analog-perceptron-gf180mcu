* Extracted by KLayout with GF180MCU LVS runset on : 11/09/2026 19:28

.SUBCKT io_secondary_5p0 ASIG5V to_gate VDD VSS
D$1 VSS to_gate diode_nd2ps_06v0 A=400P P=160U
D$5 to_gate VDD diode_pd2nw_06v0 A=400P P=160U
R$9 to_gate ASIG5V VDD 87.5 ppolyf_u L=10U W=40U
.ENDS io_secondary_5p0
