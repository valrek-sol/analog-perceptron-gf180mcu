* perceptron_core_pex_c — Magic C extraction of perceptron_core (layout/perceptron/perceptron_core.gds)
* generated by pex/pex.tcl, see pex/out/env.txt for provenance
* ports (schematic order): VDD V_shift V_w1 I_x1 V_out_perceptron V_b I_x2 V_w2 VSS
* NGSPICE file created from perceptron_core.ext - technology: gf180mcuD

.subckt perceptron_core_pex_c VDD V_shift V_w1 I_x1 V_out_perceptron V_b I_x2 V_w2 VSS
X0 a_8355_9194# tanh_ota_0.V_ref tanh_ota_0.V_in_p VSS nfet_03v3 ad=0.65p pd=3.02u as=0.65p ps=3.02u w=2.5u l=0.5u
X1 a_3415_6100# tanh_ota_0.V_ref tanh_ota_0.V_in_n VSS nfet_03v3 ad=0.65p pd=3.02u as=0.65p ps=3.02u w=2.5u l=0.5u
X2 a_2717_18262# a_2717_15824# VSS ppolyf_u_1k r_width=3u r_length=11.55u
X3 a_8355_9194# V_b tanh_ota_0.V_in_n VSS nfet_03v3 ad=0.65p pd=3.02u as=0.65p ps=3.02u w=2.5u l=0.5u
X4 VDD a_14690_20226# a_14690_20226# VDD pfet_03v3 ad=2.6p pd=10.52u as=2.6p ps=10.52u w=10u l=2u
X5 a_8355_9194# V_b tanh_ota_0.V_in_n VSS nfet_03v3 ad=0.65p pd=3.02u as=0.65p ps=3.02u w=2.5u l=0.5u
X6 a_3415_6100# V_w2 tanh_ota_0.V_in_p VSS nfet_03v3 ad=0.65p pd=3.02u as=0.65p ps=3.02u w=2.5u l=0.5u
X7 a_3619_22696# V_w1 tanh_ota_0.V_in_n VSS nfet_03v3 ad=0.65p pd=3.02u as=0.65p ps=3.02u w=2.5u l=0.5u
X8 a_3598_19300# voltage_reference_0.v_1_25 a_3619_22696# VSS nfet_03v3 ad=1.3p pd=5.52u as=1.3p ps=5.52u w=5u l=0.5u
X9 a_7766_18788# VDD VDD VDD pfet_03v3 ad=1.3p pd=5.52u as=3.25p ps=11.3u w=5u l=0.5u
X10 a_19854_15770# a_26642_16152# VSS ppolyf_u_1k r_width=3u r_length=23u
X11 a_8355_9194# tanh_ota_0.V_ref tanh_ota_0.V_in_p VSS nfet_03v3 ad=0.65p pd=3.02u as=0.65p ps=3.02u w=2.5u l=0.5u
X12 a_3619_22696# tanh_ota_0.V_ref tanh_ota_0.V_in_p VSS nfet_03v3 ad=0.65p pd=3.02u as=0.65p ps=3.02u w=2.5u l=0.5u
X13 a_3619_22696# tanh_ota_0.V_ref tanh_ota_0.V_in_p VSS nfet_03v3 ad=0.65p pd=3.02u as=0.65p ps=3.02u w=2.5u l=0.5u
X14 a_8559_11644# VSS VSS VSS nfet_03v3 ad=1.3p pd=5.52u as=3.05p ps=11.22u w=5u l=0.5u
X15 a_3619_22696# V_w1 tanh_ota_0.V_in_n VSS nfet_03v3 ad=0.65p pd=3.02u as=0.65p ps=3.02u w=2.5u l=0.5u
X16 a_3415_21020# tanh_ota_0.V_ref tanh_ota_0.V_in_n VSS nfet_03v3 ad=0.65p pd=3.02u as=0.65p ps=3.02u w=2.5u l=0.5u
X17 a_11555_17360# a_11555_17360# VSS VSS nfet_03v3 ad=0.39p pd=2.02u as=0.39p ps=2.02u w=1.5u l=0.5u
X18 a_11555_17360# a_11555_17360# VSS VSS nfet_03v3 ad=0.39p pd=2.02u as=0.39p ps=2.02u w=1.5u l=0.5u
X19 a_13330_17856# VDD VSS ppolyf_u_1k r_width=3u r_length=30u
X20 a_3619_2602# V_w2 tanh_ota_0.V_in_n VSS nfet_03v3 ad=0.65p pd=3.02u as=0.65p ps=3.02u w=2.5u l=0.5u
X21 a_3415_21020# V_w1 tanh_ota_0.V_in_p VSS nfet_03v3 ad=0.65p pd=3.02u as=0.65p ps=3.02u w=2.5u l=0.5u
X22 VDD a_13492_24053# voltage_reference_0.v_1_25 VSS nfet_03v3 ad=2.6p pd=10.52u as=2.6p ps=10.52u w=10u l=1u
X23 a_7766_18788# VSS VSS VSS nfet_03v3 ad=1.3p pd=5.52u as=3.05p ps=11.22u w=5u l=0.5u
X24 a_13250_5878# VSS VSS VSS nfet_03v3 ad=1.3p pd=5.52u as=3.05p ps=11.22u w=5u l=1u
X25 VSS VSS tanh_ota_0.V_in_n VSS nfet_03v3 ad=1.525p pd=6.22u as=0.65p ps=3.02u w=2.5u l=0.5u
X26 a_3598_19300# a_4405_15824# VSS ppolyf_u_1k r_width=3u r_length=11.55u
X27 a_23777_13400# VDD VDD VDD pfet_03v3 ad=2.6p pd=10.52u as=6.5p ps=21.3u w=10u l=1u
X28 a_3561_18262# a_4405_15824# VSS ppolyf_u_1k r_width=3u r_length=11.55u
X29 VSS VSS tanh_ota_0.V_in_n VSS nfet_03v3 ad=1.525p pd=6.22u as=0.65p ps=3.02u w=2.5u l=0.5u
X30 a_3415_6100# tanh_ota_0.V_ref tanh_ota_0.V_in_n VSS nfet_03v3 ad=0.65p pd=3.02u as=0.65p ps=3.02u w=2.5u l=0.5u
X31 a_7657_6436# VSS VSS VSS nfet_03v3 ad=1.04p pd=4.52u as=2.44p ps=9.22u w=4u l=1u
X32 VSS a_11555_17360# a_11555_17360# VSS nfet_03v3 ad=0.39p pd=2.02u as=0.39p ps=2.02u w=1.5u l=0.5u
X33 VSS a_11555_17360# a_11555_17360# VSS nfet_03v3 ad=0.39p pd=2.02u as=0.39p ps=2.02u w=1.5u l=0.5u
X34 VSS voltage_reference_0.v_1_25 VSS ppolyf_u_1k r_width=3u r_length=20u
X35 tanh_ota_0.V_in_n tanh_ota_0.V_ref a_8559_11644# VSS nfet_03v3 ad=0.65p pd=3.02u as=0.65p ps=3.02u w=2.5u l=0.5u
X36 tanh_ota_0.V_in_p VSS VSS VSS nfet_03v3 ad=0.65p pd=3.02u as=1.525p ps=6.22u w=2.5u l=0.5u
X37 a_7766_18788# tanh_ota_0.V_in_p a_10295_19296# VSS nfet_03v3 ad=1.3p pd=5.52u as=1.3p ps=5.52u w=5u l=0.5u
X38 VSS VSS a_13382_5774# VSS nfet_03v3 ad=1.525p pd=6.22u as=0.65p ps=3.02u w=2.5u l=2u
X39 VDD a_13492_24053# voltage_reference_0.v_1_25 VSS nfet_03v3 ad=2.6p pd=10.52u as=2.6p ps=10.52u w=10u l=1u
X40 a_8355_9194# tanh_ota_0.V_ref tanh_ota_0.V_in_p VSS nfet_03v3 ad=0.65p pd=3.02u as=0.65p ps=3.02u w=2.5u l=0.5u
X41 tanh_ota_0.V_in_n tanh_ota_0.V_ref a_8559_11644# VSS nfet_03v3 ad=0.65p pd=3.02u as=0.65p ps=3.02u w=2.5u l=0.5u
X42 VDD a_7766_18788# a_7766_18788# VDD pfet_03v3 ad=1.3p pd=5.52u as=1.3p ps=5.52u w=5u l=0.5u
X43 a_8355_9194# V_b tanh_ota_0.V_in_n VSS nfet_03v3 ad=0.65p pd=3.02u as=0.65p ps=3.02u w=2.5u l=0.5u
X44 VSS VSS a_3415_21020# VSS nfet_03v3 ad=3.05p pd=11.22u as=1.3p ps=5.52u w=5u l=0.5u
X45 a_23777_13400# a_19854_15770# a_22199_13400# VDD pfet_03v3 ad=2.6p pd=10.52u as=2.6p ps=10.52u w=10u l=1u
X46 VSS a_13250_5878# a_13382_5774# VSS nfet_03v3 ad=0.65p pd=3.02u as=0.65p ps=3.02u w=2.5u l=2u
X47 a_3415_6100# VSS VSS VSS nfet_03v3 ad=1.3p pd=5.52u as=3.05p ps=11.22u w=5u l=0.5u
X48 a_3619_22696# V_w1 tanh_ota_0.V_in_n VSS nfet_03v3 ad=0.65p pd=3.02u as=0.65p ps=3.02u w=2.5u l=0.5u
X49 a_2717_18262# gilbert_multiplier_current_2.V_x_n a_3415_21020# VSS nfet_03v3 ad=1.3p pd=5.52u as=1.3p ps=5.52u w=5u l=0.5u
X50 a_3619_2602# tanh_ota_0.V_ref tanh_ota_0.V_in_p VSS nfet_03v3 ad=0.65p pd=3.02u as=0.65p ps=3.02u w=2.5u l=0.5u
X51 a_3619_22696# tanh_ota_0.V_ref tanh_ota_0.V_in_p VSS nfet_03v3 ad=0.65p pd=3.02u as=0.65p ps=3.02u w=2.5u l=0.5u
X52 VDD a_13492_1131# tanh_ota_0.V_ref VSS nfet_03v3 ad=2.6p pd=10.52u as=2.6p ps=10.52u w=10u l=1u
X53 a_3415_21020# tanh_ota_0.V_ref tanh_ota_0.V_in_n VSS nfet_03v3 ad=0.65p pd=3.02u as=0.65p ps=3.02u w=2.5u l=0.5u
X54 VSS a_11555_17360# a_11555_17360# VSS nfet_03v3 ad=0.39p pd=2.02u as=0.39p ps=2.02u w=1.5u l=0.5u
X55 VSS VSS a_13382_20226# VSS nfet_03v3 ad=1.525p pd=6.22u as=0.65p ps=3.02u w=2.5u l=2u
X56 VSS a_13250_5878# a_13382_5774# VSS nfet_03v3 ad=0.65p pd=3.02u as=0.65p ps=3.02u w=2.5u l=2u
X57 VSS VSS a_8559_11644# VSS nfet_03v3 ad=3.05p pd=11.22u as=1.3p ps=5.52u w=5u l=0.5u
X58 a_3415_21020# V_w1 tanh_ota_0.V_in_p VSS nfet_03v3 ad=0.65p pd=3.02u as=0.65p ps=3.02u w=2.5u l=0.5u
X59 a_3415_21020# V_w1 tanh_ota_0.V_in_p VSS nfet_03v3 ad=0.65p pd=3.02u as=0.65p ps=3.02u w=2.5u l=0.5u
X60 gilbert_multiplier_current_2.V_x_n voltage_reference_0.v_1_25 I_x1 VSS nfet_03v3 ad=0.65p pd=3.02u as=1.525p ps=6.22u w=2.5u l=0.5u
X61 a_3415_6100# tanh_ota_0.V_ref tanh_ota_0.V_in_n VSS nfet_03v3 ad=0.65p pd=3.02u as=0.65p ps=3.02u w=2.5u l=0.5u
X62 VDD a_11839_24980# VSS ppolyf_u_1k r_width=3u r_length=22u
X63 a_3415_21020# tanh_ota_0.V_ref tanh_ota_0.V_in_n VSS nfet_03v3 ad=0.65p pd=3.02u as=0.65p ps=3.02u w=2.5u l=0.5u
X64 VSS a_13250_5878# a_13382_20226# VSS nfet_03v3 ad=0.65p pd=3.02u as=0.65p ps=3.02u w=2.5u l=2u
X65 a_21914_17004# a_26642_17856# VSS ppolyf_u_1k r_width=3u r_length=23u
X66 a_14558_5878# a_19467_13334# VSS ppolyf_u_1k r_width=3u r_length=20u
X67 tanh_ota_0.V_ref a_13492_1131# VDD VSS nfet_03v3 ad=2.6p pd=10.52u as=2.6p ps=10.52u w=10u l=1u
X68 a_10295_19296# a_11555_17360# VSS VSS nfet_03v3 ad=0.39p pd=2.02u as=0.39p ps=2.02u w=1.5u l=0.5u
X69 VDD a_19458_12220# a_22199_13400# VDD pfet_03v3 ad=1.3p pd=5.52u as=1.3p ps=5.52u w=5u l=1u
X70 a_3619_2602# voltage_reference_0.v_1_25 a_3598_8020# VSS nfet_03v3 ad=1.3p pd=5.52u as=1.3p ps=5.52u w=5u l=0.5u
X71 V_out_perceptron a_8953_14522# VSS ppolyf_u_1k r_width=3u r_length=15u
X72 a_3598_8020# tanh_ota_0.V_ref VSS VSS nfet_03v3 ad=1.04p pd=4.52u as=1.04p ps=4.52u w=4u l=1u
X73 a_11555_17360# a_11555_17360# VSS VSS nfet_03v3 ad=0.39p pd=2.02u as=0.39p ps=2.02u w=1.5u l=0.5u
X74 VSS VSS a_14690_20226# VSS nfet_03v3 ad=3.05p pd=11.22u as=1.3p ps=5.52u w=5u l=2u
X75 tanh_ota_0.V_in_p V_b a_8559_11644# VSS nfet_03v3 ad=0.65p pd=3.02u as=0.65p ps=3.02u w=2.5u l=0.5u
X76 tanh_ota_0.V_in_p tanh_ota_0.V_ref a_3619_2602# VSS nfet_03v3 ad=0.65p pd=3.02u as=0.65p ps=3.02u w=2.5u l=0.5u
X77 a_3619_2602# V_w2 tanh_ota_0.V_in_n VSS nfet_03v3 ad=0.65p pd=3.02u as=0.65p ps=3.02u w=2.5u l=0.5u
X78 VSS tanh_ota_0.V_ref a_2717_18262# VSS nfet_03v3 ad=1.04p pd=4.52u as=1.04p ps=4.52u w=4u l=1u
X79 tanh_ota_0.V_in_n tanh_ota_0.V_ref a_8559_11644# VSS nfet_03v3 ad=0.65p pd=3.02u as=0.65p ps=3.02u w=2.5u l=0.5u
X80 a_8355_9194# VSS VSS VSS nfet_03v3 ad=1.3p pd=5.52u as=3.05p ps=11.22u w=5u l=0.5u
X81 a_3415_6100# V_w2 tanh_ota_0.V_in_p VSS nfet_03v3 ad=0.65p pd=3.02u as=0.65p ps=3.02u w=2.5u l=0.5u
X82 a_7311_22424# a_11839_23276# VSS ppolyf_u_1k r_width=3u r_length=22u
X83 voltage_reference_0.v_1_25 a_13492_24053# VDD VSS nfet_03v3 ad=2.6p pd=10.52u as=2.6p ps=10.52u w=10u l=1u
X84 a_7766_18788# a_7766_18788# VDD VDD pfet_03v3 ad=1.3p pd=5.52u as=1.3p ps=5.52u w=5u l=0.5u
X85 a_13382_20226# voltage_reference_0.v_1_25 a_13492_24053# VSS nfet_03v3 ad=1.3p pd=5.52u as=1.3p ps=5.52u w=5u l=2u
X86 tanh_ota_0.V_in_p V_b a_8559_11644# VSS nfet_03v3 ad=0.65p pd=3.02u as=0.65p ps=3.02u w=2.5u l=0.5u
X87 tanh_ota_0.V_in_n V_w2 a_3619_2602# VSS nfet_03v3 ad=0.65p pd=3.02u as=0.65p ps=3.02u w=2.5u l=0.5u
X88 VSS a_11555_17360# a_11555_17360# VSS nfet_03v3 ad=0.39p pd=2.02u as=0.39p ps=2.02u w=1.5u l=0.5u
X89 tanh_ota_0.V_in_n VSS VSS VSS nfet_03v3 ad=0.65p pd=3.02u as=1.525p ps=6.22u w=2.5u l=0.5u
X90 a_3415_6100# tanh_ota_0.V_ref tanh_ota_0.V_in_n VSS nfet_03v3 ad=0.65p pd=3.02u as=0.65p ps=3.02u w=2.5u l=0.5u
X91 VDD a_13492_24053# voltage_reference_0.v_1_25 VSS nfet_03v3 ad=2.6p pd=10.52u as=2.6p ps=10.52u w=10u l=1u
X92 a_13250_5878# a_13250_5878# VSS VSS nfet_03v3 ad=1.3p pd=5.52u as=1.3p ps=5.52u w=5u l=1u
X93 tanh_ota_0.V_in_p tanh_ota_0.V_ref a_8355_9194# VSS nfet_03v3 ad=0.65p pd=3.02u as=0.65p ps=3.02u w=2.5u l=0.5u
X94 a_8559_11644# voltage_reference_0.v_1_15 a_9196_7474# VSS nfet_03v3 ad=1.3p pd=5.52u as=1.3p ps=5.52u w=5u l=0.5u
X95 VDD VDD a_7766_18788# VDD pfet_03v3 ad=3.25p pd=11.3u as=1.3p ps=5.52u w=5u l=0.5u
X96 VSS VSS a_3619_2602# VSS nfet_03v3 ad=3.05p pd=11.22u as=1.3p ps=5.52u w=5u l=0.5u
X97 tanh_ota_0.V_in_n V_w1 a_3619_22696# VSS nfet_03v3 ad=0.65p pd=3.02u as=0.65p ps=3.02u w=2.5u l=0.5u
X98 VSS VSS a_3598_19300# VSS nfet_03v3 ad=2.44p pd=9.22u as=1.04p ps=4.52u w=4u l=1u
X99 tanh_ota_0.V_in_n V_w2 a_3619_2602# VSS nfet_03v3 ad=0.65p pd=3.02u as=0.65p ps=3.02u w=2.5u l=0.5u
X100 VSS a_11555_17360# a_11555_17360# VSS nfet_03v3 ad=0.39p pd=2.02u as=0.39p ps=2.02u w=1.5u l=0.5u
X101 a_13382_20226# a_13250_5878# VSS VSS nfet_03v3 ad=0.65p pd=3.02u as=0.65p ps=3.02u w=2.5u l=2u
X102 a_19914_7960# VDD VSS ppolyf_u_1k r_width=3u r_length=33u
X103 a_3415_21020# V_w1 tanh_ota_0.V_in_p VSS nfet_03v3 ad=0.65p pd=3.02u as=0.65p ps=3.02u w=2.5u l=0.5u
X104 a_19458_12220# VDD VDD VDD pfet_03v3 ad=1.3p pd=5.52u as=3.25p ps=11.3u w=5u l=1u
X105 a_13382_5774# a_13250_5878# VSS VSS nfet_03v3 ad=0.65p pd=3.02u as=0.65p ps=3.02u w=2.5u l=2u
X106 a_3415_21020# tanh_ota_0.V_ref tanh_ota_0.V_in_n VSS nfet_03v3 ad=0.65p pd=3.02u as=0.65p ps=3.02u w=2.5u l=0.5u
X107 voltage_reference_0.v_1_25 a_13492_24053# VDD VSS nfet_03v3 ad=2.6p pd=10.52u as=2.6p ps=10.52u w=10u l=1u
X108 a_14690_20226# VDD VDD VDD pfet_03v3 ad=2.6p pd=10.52u as=6.5p ps=21.3u w=10u l=2u
X109 VSS a_23777_13400# a_23777_13400# VSS nfet_03v3 ad=1.3p pd=5.52u as=1.3p ps=5.52u w=5u l=1u
X110 tanh_ota_0.V_in_p tanh_ota_0.V_ref a_3619_2602# VSS nfet_03v3 ad=0.65p pd=3.02u as=0.65p ps=3.02u w=2.5u l=0.5u
X111 a_13382_20226# a_13250_5878# VSS VSS nfet_03v3 ad=0.65p pd=3.02u as=0.65p ps=3.02u w=2.5u l=2u
X112 I_x2 voltage_reference_0.v_1_25 gilbert_multiplier_current_1.V_x_n VSS nfet_03v3 ad=1.525p pd=6.22u as=0.65p ps=3.02u w=2.5u l=0.5u
X113 a_13382_5774# a_13250_5878# VSS VSS nfet_03v3 ad=0.65p pd=3.02u as=0.65p ps=3.02u w=2.5u l=2u
X114 tanh_ota_0.V_in_n tanh_ota_0.V_ref a_3415_6100# VSS nfet_03v3 ad=0.65p pd=3.02u as=0.65p ps=3.02u w=2.5u l=0.5u
X115 a_13382_5774# VSS VSS VSS nfet_03v3 ad=0.65p pd=3.02u as=1.525p ps=6.22u w=2.5u l=2u
X116 tanh_ota_0.V_in_p V_w2 a_3415_6100# VSS nfet_03v3 ad=0.65p pd=3.02u as=0.65p ps=3.02u w=2.5u l=0.5u
X117 VDD VDD a_22199_13400# VDD pfet_03v3 ad=3.25p pd=11.3u as=1.3p ps=5.52u w=5u l=1u
X118 a_14558_5878# a_26642_10516# VSS ppolyf_u_1k r_width=3u r_length=33u
X119 a_14690_20226# a_14558_20330# a_13382_20226# VSS nfet_03v3 ad=1.3p pd=5.52u as=1.3p ps=5.52u w=5u l=2u
X120 tanh_ota_0.V_in_n tanh_ota_0.V_ref a_8559_11644# VSS nfet_03v3 ad=0.65p pd=3.02u as=0.65p ps=3.02u w=2.5u l=0.5u
X121 tanh_ota_0.V_in_p V_b a_8559_11644# VSS nfet_03v3 ad=0.65p pd=3.02u as=0.65p ps=3.02u w=2.5u l=0.5u
X122 VDD a_13492_1131# tanh_ota_0.V_ref VSS nfet_03v3 ad=2.6p pd=10.52u as=2.6p ps=10.52u w=10u l=1u
X123 a_10295_19296# tanh_ota_0.V_in_n V_out_perceptron VSS nfet_03v3 ad=1.3p pd=5.52u as=1.3p ps=5.52u w=5u l=0.5u
X124 a_13492_24053# voltage_reference_0.v_1_25 a_13382_20226# VSS nfet_03v3 ad=1.3p pd=5.52u as=1.3p ps=5.52u w=5u l=2u
X125 a_13330_16152# a_19458_15300# VSS ppolyf_u_1k r_width=3u r_length=30u
X126 tanh_ota_0.V_in_n V_b a_8355_9194# VSS nfet_03v3 ad=0.65p pd=3.02u as=0.65p ps=3.02u w=2.5u l=0.5u
X127 tanh_ota_0.V_in_n V_b a_8355_9194# VSS nfet_03v3 ad=0.65p pd=3.02u as=0.65p ps=3.02u w=2.5u l=0.5u
X128 a_3415_6100# gilbert_multiplier_current_1.V_x_n a_2717_9730# VSS nfet_03v3 ad=1.3p pd=5.52u as=1.3p ps=5.52u w=5u l=0.5u
X129 a_7766_18788# a_7766_18788# VDD VDD pfet_03v3 ad=1.3p pd=5.52u as=1.3p ps=5.52u w=5u l=0.5u
X130 VSS a_11555_17360# a_11555_17360# VSS nfet_03v3 ad=0.39p pd=2.02u as=0.39p ps=2.02u w=1.5u l=0.5u
X131 VSS a_11555_17360# a_11555_17360# VSS nfet_03v3 ad=0.39p pd=2.02u as=0.39p ps=2.02u w=1.5u l=0.5u
X132 tanh_ota_0.V_in_p VSS VSS VSS nfet_03v3 ad=0.65p pd=3.02u as=1.525p ps=6.22u w=2.5u l=0.5u
X133 VSS VSS VDD VSS nfet_03v3 ad=6.1p pd=21.22u as=2.6p ps=10.52u w=10u l=1u
X134 voltage_reference_0.v_1_25 a_13492_24053# VDD VSS nfet_03v3 ad=2.6p pd=10.52u as=2.6p ps=10.52u w=10u l=1u
X135 tanh_ota_0.V_in_p tanh_ota_0.V_ref a_3619_22696# VSS nfet_03v3 ad=0.65p pd=3.02u as=0.65p ps=3.02u w=2.5u l=0.5u
X136 tanh_ota_0.V_in_p tanh_ota_0.V_ref a_3619_22696# VSS nfet_03v3 ad=0.65p pd=3.02u as=0.65p ps=3.02u w=2.5u l=0.5u
X137 a_22199_13400# a_19458_12220# VDD VDD pfet_03v3 ad=1.3p pd=5.52u as=1.3p ps=5.52u w=5u l=1u
X138 a_3415_6100# V_w2 tanh_ota_0.V_in_p VSS nfet_03v3 ad=0.65p pd=3.02u as=0.65p ps=3.02u w=2.5u l=0.5u
X139 tanh_ota_0.V_in_n VSS VSS VSS nfet_03v3 ad=0.65p pd=3.02u as=1.525p ps=6.22u w=2.5u l=0.5u
X140 a_2717_12168# a_2717_9730# VSS ppolyf_u_1k r_width=3u r_length=11.55u
X141 tanh_ota_0.V_in_p V_w1 a_3415_21020# VSS nfet_03v3 ad=0.65p pd=3.02u as=0.65p ps=3.02u w=2.5u l=0.5u
X142 a_9805_17650# tanh_ota_0.V_ref VSS ppolyf_u_1k r_width=3u r_length=15u
X143 tanh_ota_0.V_in_n VSS VSS VSS nfet_03v3 ad=0.65p pd=3.02u as=1.525p ps=6.22u w=2.5u l=0.5u
X144 VSS tanh_ota_0.V_ref a_9196_7474# VSS nfet_03v3 ad=1.04p pd=4.52u as=1.04p ps=4.52u w=4u l=1u
X145 a_11555_17360# a_11555_17360# VSS VSS nfet_03v3 ad=0.39p pd=2.02u as=0.39p ps=2.02u w=1.5u l=0.5u
X146 a_2717_9730# tanh_ota_0.V_ref VSS VSS nfet_03v3 ad=1.04p pd=4.52u as=1.04p ps=4.52u w=4u l=1u
X147 VSS VSS a_3598_8020# VSS nfet_03v3 ad=2.44p pd=9.22u as=1.04p ps=4.52u w=4u l=1u
X148 VDD a_13492_1131# tanh_ota_0.V_ref VSS nfet_03v3 ad=2.6p pd=10.52u as=2.6p ps=10.52u w=10u l=1u
X149 a_13330_9664# a_19458_8812# VSS ppolyf_u_1k r_width=3u r_length=30u
X150 VDD VSS VSS VSS nfet_03v3 ad=2.6p pd=10.52u as=6.1p ps=21.22u w=10u l=1u
X151 a_13330_11368# a_19458_12220# VSS ppolyf_u_1k r_width=3u r_length=30u
X152 a_8355_9194# voltage_reference_0.v_1_25 a_7657_6436# VSS nfet_03v3 ad=1.3p pd=5.52u as=1.3p ps=5.52u w=5u l=0.5u
X153 tanh_ota_0.V_in_n V_w2 a_3619_2602# VSS nfet_03v3 ad=0.65p pd=3.02u as=0.65p ps=3.02u w=2.5u l=0.5u
X154 VSS a_11555_17360# a_11555_17360# VSS nfet_03v3 ad=0.39p pd=2.02u as=0.39p ps=2.02u w=1.5u l=0.5u
X155 voltage_reference_0.v_1_25 a_13492_24053# VDD VSS nfet_03v3 ad=2.6p pd=10.52u as=2.6p ps=10.52u w=10u l=1u
X156 VSS a_13250_5878# a_13250_5878# VSS nfet_03v3 ad=1.3p pd=5.52u as=1.3p ps=5.52u w=5u l=1u
X157 tanh_ota_0.V_in_p V_w2 a_3415_6100# VSS nfet_03v3 ad=0.65p pd=3.02u as=0.65p ps=3.02u w=2.5u l=0.5u
X158 VDD a_7766_18788# V_out_perceptron VDD pfet_03v3 ad=1.3p pd=5.52u as=1.3p ps=5.52u w=5u l=0.5u
X159 a_22199_13400# a_19854_15770# a_23777_13400# VDD pfet_03v3 ad=2.6p pd=10.52u as=2.6p ps=10.52u w=10u l=1u
X160 tanh_ota_0.V_in_p VSS VSS VSS nfet_03v3 ad=0.65p pd=3.02u as=1.525p ps=6.22u w=2.5u l=0.5u
X161 VSS a_13250_5878# a_13382_20226# VSS nfet_03v3 ad=0.65p pd=3.02u as=0.65p ps=3.02u w=2.5u l=2u
X162 a_21914_17004# a_26642_16152# VSS ppolyf_u_1k r_width=3u r_length=23u
X163 tanh_ota_0.V_in_p tanh_ota_0.V_ref a_8355_9194# VSS nfet_03v3 ad=0.65p pd=3.02u as=0.65p ps=3.02u w=2.5u l=0.5u
X164 tanh_ota_0.V_in_p tanh_ota_0.V_ref a_8355_9194# VSS nfet_03v3 ad=0.65p pd=3.02u as=0.65p ps=3.02u w=2.5u l=0.5u
X165 tanh_ota_0.V_in_n tanh_ota_0.V_ref a_3415_6100# VSS nfet_03v3 ad=0.65p pd=3.02u as=0.65p ps=3.02u w=2.5u l=0.5u
X166 a_7311_22424# a_11555_17360# VSS ppolyf_u_1k r_width=3u r_length=22u
X167 tanh_ota_0.V_in_n VSS VSS VSS nfet_03v3 ad=0.65p pd=3.02u as=1.525p ps=6.22u w=2.5u l=0.5u
X168 tanh_ota_0.V_in_n V_b a_8355_9194# VSS nfet_03v3 ad=0.65p pd=3.02u as=0.65p ps=3.02u w=2.5u l=0.5u
X169 VSS VSS a_14690_5774# VSS nfet_03v3 ad=3.05p pd=11.22u as=1.3p ps=5.52u w=5u l=2u
X170 a_19914_9664# a_26642_8812# VSS ppolyf_u_1k r_width=3u r_length=33u
X171 tanh_ota_0.V_in_n V_w1 a_3619_22696# VSS nfet_03v3 ad=0.65p pd=3.02u as=0.65p ps=3.02u w=2.5u l=0.5u
X172 a_19458_12220# a_19458_12220# VDD VDD pfet_03v3 ad=1.3p pd=5.52u as=1.3p ps=5.52u w=5u l=1u
X173 tanh_ota_0.V_in_p tanh_ota_0.V_ref a_3619_22696# VSS nfet_03v3 ad=0.65p pd=3.02u as=0.65p ps=3.02u w=2.5u l=0.5u
X174 tanh_ota_0.V_in_n V_w1 a_3619_22696# VSS nfet_03v3 ad=0.65p pd=3.02u as=0.65p ps=3.02u w=2.5u l=0.5u
X175 a_3415_21020# gilbert_multiplier_current_2.V_x_n a_2717_18262# VSS nfet_03v3 ad=1.3p pd=5.52u as=1.3p ps=5.52u w=5u l=0.5u
X176 VSS a_23777_13400# voltage_reference_0.v_1_15 VSS nfet_03v3 ad=1.3p pd=5.52u as=1.3p ps=5.52u w=5u l=1u
X177 tanh_ota_0.V_in_p VSS VSS VSS nfet_03v3 ad=0.65p pd=3.02u as=1.525p ps=6.22u w=2.5u l=0.5u
X178 tanh_ota_0.V_in_p VSS VSS VSS nfet_03v3 ad=0.65p pd=3.02u as=1.525p ps=6.22u w=2.5u l=0.5u
X179 a_3415_21020# VSS VSS VSS nfet_03v3 ad=1.3p pd=5.52u as=3.05p ps=11.22u w=5u l=0.5u
X180 VSS tanh_ota_0.V_ref a_3598_19300# VSS nfet_03v3 ad=1.04p pd=4.52u as=1.04p ps=4.52u w=4u l=1u
X181 VDD a_13492_1131# tanh_ota_0.V_ref VSS nfet_03v3 ad=2.6p pd=10.52u as=2.6p ps=10.52u w=10u l=1u
X182 a_13382_5774# tanh_ota_0.V_ref a_13492_1131# VSS nfet_03v3 ad=1.3p pd=5.52u as=1.3p ps=5.52u w=5u l=2u
X183 tanh_ota_0.V_in_p tanh_ota_0.V_ref a_3619_2602# VSS nfet_03v3 ad=0.65p pd=3.02u as=0.65p ps=3.02u w=2.5u l=0.5u
X184 tanh_ota_0.V_in_n tanh_ota_0.V_ref a_3415_21020# VSS nfet_03v3 ad=0.65p pd=3.02u as=0.65p ps=3.02u w=2.5u l=0.5u
X185 a_13330_17856# a_19458_17004# VSS ppolyf_u_1k r_width=3u r_length=30u
X186 a_22199_13400# VDD VDD VDD pfet_03v3 ad=1.3p pd=5.52u as=3.25p ps=11.3u w=5u l=1u
X187 tanh_ota_0.V_in_p VSS VSS VSS nfet_03v3 ad=0.65p pd=3.02u as=1.525p ps=6.22u w=2.5u l=0.5u
X188 VSS a_11555_17360# a_11555_17360# VSS nfet_03v3 ad=0.39p pd=2.02u as=0.39p ps=2.02u w=1.5u l=0.5u
X189 VSS VSS tanh_ota_0.V_in_n VSS nfet_03v3 ad=1.525p pd=6.22u as=0.65p ps=3.02u w=2.5u l=0.5u
X190 a_13382_5774# a_14558_5878# a_14690_5774# VSS nfet_03v3 ad=1.3p pd=5.52u as=1.3p ps=5.52u w=5u l=2u
X191 tanh_ota_0.V_in_n tanh_ota_0.V_ref a_3415_21020# VSS nfet_03v3 ad=0.65p pd=3.02u as=0.65p ps=3.02u w=2.5u l=0.5u
X192 VSS a_11555_17360# a_11555_17360# VSS nfet_03v3 ad=0.39p pd=2.02u as=0.39p ps=2.02u w=1.5u l=0.5u
X193 a_13382_20226# a_14558_20330# a_14690_20226# VSS nfet_03v3 ad=1.3p pd=5.52u as=1.3p ps=5.52u w=5u l=2u
X194 tanh_ota_0.V_in_p V_w2 a_3415_6100# VSS nfet_03v3 ad=0.65p pd=3.02u as=0.65p ps=3.02u w=2.5u l=0.5u
X195 VSS tanh_ota_0.V_ref a_7657_6436# VSS nfet_03v3 ad=1.04p pd=4.52u as=1.04p ps=4.52u w=4u l=1u
X196 VDD a_7766_18788# V_out_perceptron VDD pfet_03v3 ad=1.3p pd=5.52u as=1.3p ps=5.52u w=5u l=0.5u
X197 a_7657_6436# a_7657_3998# VSS ppolyf_u_1k r_width=3u r_length=11.55u
X198 a_8559_11644# tanh_ota_0.V_ref tanh_ota_0.V_in_n VSS nfet_03v3 ad=0.65p pd=3.02u as=0.65p ps=3.02u w=2.5u l=0.5u
X199 tanh_ota_0.V_ref a_13492_1131# VDD VSS nfet_03v3 ad=2.6p pd=10.52u as=2.6p ps=10.52u w=10u l=1u
X200 a_11555_17360# a_11555_17360# VSS VSS nfet_03v3 ad=0.39p pd=2.02u as=0.39p ps=2.02u w=1.5u l=0.5u
X201 a_8559_11644# V_b tanh_ota_0.V_in_p VSS nfet_03v3 ad=0.65p pd=3.02u as=0.65p ps=3.02u w=2.5u l=0.5u
X202 a_3598_8020# VSS VSS VSS nfet_03v3 ad=1.04p pd=4.52u as=2.44p ps=9.22u w=4u l=1u
X203 VDD a_13492_1131# tanh_ota_0.V_ref VSS nfet_03v3 ad=2.6p pd=10.52u as=2.6p ps=10.52u w=10u l=1u
X204 tanh_ota_0.V_in_n V_b a_8355_9194# VSS nfet_03v3 ad=0.65p pd=3.02u as=0.65p ps=3.02u w=2.5u l=0.5u
X205 VSS VSS tanh_ota_0.V_in_p VSS nfet_03v3 ad=1.525p pd=6.22u as=0.65p ps=3.02u w=2.5u l=0.5u
X206 tanh_ota_0.V_in_p tanh_ota_0.V_ref a_8355_9194# VSS nfet_03v3 ad=0.65p pd=3.02u as=0.65p ps=3.02u w=2.5u l=0.5u
X207 a_22199_13400# a_19458_12220# VDD VDD pfet_03v3 ad=1.3p pd=5.52u as=1.3p ps=5.52u w=5u l=1u
X208 a_19914_9664# a_26642_10516# VSS ppolyf_u_1k r_width=3u r_length=33u
X209 a_3619_22696# voltage_reference_0.v_1_25 a_3598_19300# VSS nfet_03v3 ad=1.3p pd=5.52u as=1.3p ps=5.52u w=5u l=0.5u
X210 VDD tanh_ota_0.V_in_n VSS ppolyf_u_1k r_width=3u r_length=7.3u
X211 V_out_perceptron tanh_ota_0.V_in_n a_10295_19296# VSS nfet_03v3 ad=1.3p pd=5.52u as=1.3p ps=5.52u w=5u l=0.5u
X212 a_2717_9730# gilbert_multiplier_current_1.V_x_n a_3415_6100# VSS nfet_03v3 ad=1.3p pd=5.52u as=1.3p ps=5.52u w=5u l=0.5u
X213 tanh_ota_0.V_in_p tanh_ota_0.V_ref a_3619_22696# VSS nfet_03v3 ad=0.65p pd=3.02u as=0.65p ps=3.02u w=2.5u l=0.5u
X214 a_3619_22696# VSS VSS VSS nfet_03v3 ad=1.3p pd=5.52u as=3.05p ps=11.22u w=5u l=0.5u
X215 tanh_ota_0.V_in_n V_w1 a_3619_22696# VSS nfet_03v3 ad=0.65p pd=3.02u as=0.65p ps=3.02u w=2.5u l=0.5u
X216 a_11555_17360# a_11555_17360# VSS VSS nfet_03v3 ad=0.39p pd=2.02u as=0.39p ps=2.02u w=1.5u l=0.5u
X217 VSS VSS tanh_ota_0.V_in_p VSS nfet_03v3 ad=1.525p pd=6.22u as=0.65p ps=3.02u w=2.5u l=0.5u
X218 tanh_ota_0.V_in_p V_w1 a_3415_21020# VSS nfet_03v3 ad=0.65p pd=3.02u as=0.65p ps=3.02u w=2.5u l=0.5u
X219 a_13250_5878# a_19458_15300# VSS ppolyf_u_1k r_width=3u r_length=30u
X220 tanh_ota_0.V_in_n tanh_ota_0.V_ref a_3415_21020# VSS nfet_03v3 ad=0.65p pd=3.02u as=0.65p ps=3.02u w=2.5u l=0.5u
X221 VDD VDD a_14690_20226# VDD pfet_03v3 ad=6.5p pd=21.3u as=2.6p ps=10.52u w=10u l=2u
X222 a_21914_18708# a_26642_17856# VSS ppolyf_u_1k r_width=3u r_length=23u
X223 tanh_ota_0.V_in_p tanh_ota_0.V_ref a_3619_2602# VSS nfet_03v3 ad=0.65p pd=3.02u as=0.65p ps=3.02u w=2.5u l=0.5u
X224 VDD a_13492_24053# voltage_reference_0.v_1_25 VSS nfet_03v3 ad=2.6p pd=10.52u as=2.6p ps=10.52u w=10u l=1u
X225 a_11555_17360# a_11555_17360# VSS VSS nfet_03v3 ad=0.39p pd=2.02u as=0.39p ps=2.02u w=1.5u l=0.5u
X226 VSS VSS tanh_ota_0.V_in_p VSS nfet_03v3 ad=1.525p pd=6.22u as=0.65p ps=3.02u w=2.5u l=0.5u
X227 a_7657_6436# tanh_ota_0.V_ref VSS VSS nfet_03v3 ad=1.04p pd=4.52u as=1.04p ps=4.52u w=4u l=1u
X228 tanh_ota_0.V_in_p V_w1 a_3415_21020# VSS nfet_03v3 ad=0.65p pd=3.02u as=0.65p ps=3.02u w=2.5u l=0.5u
X229 a_13330_11368# a_19458_10516# VSS ppolyf_u_1k r_width=3u r_length=30u
X230 tanh_ota_0.V_in_n VSS VSS VSS nfet_03v3 ad=0.65p pd=3.02u as=1.525p ps=6.22u w=2.5u l=0.5u
X231 tanh_ota_0.V_in_n VSS VSS VSS nfet_03v3 ad=0.65p pd=3.02u as=1.525p ps=6.22u w=2.5u l=0.5u
X232 voltage_reference_0.v_1_25 a_13492_24053# VDD VSS nfet_03v3 ad=2.6p pd=10.52u as=2.6p ps=10.52u w=10u l=1u
X233 VSS VSS VSS VSS nfet_03v3 ad=0.39p pd=2.02u as=0.18551n ps=0.72964m w=1.5u l=0.5u
X234 VDD a_14690_20226# a_13492_24053# VDD pfet_03v3 ad=2.6p pd=10.52u as=2.6p ps=10.52u w=10u l=2u
X235 a_21914_18708# VSS VSS ppolyf_u_1k r_width=3u r_length=23u
X236 VSS VSS a_23777_13400# VSS nfet_03v3 ad=3.05p pd=11.22u as=1.3p ps=5.52u w=5u l=1u
X237 a_7311_24128# a_11839_24980# VSS ppolyf_u_1k r_width=3u r_length=22u
X238 gilbert_multiplier_current_1.V_x_n voltage_reference_0.v_1_25 I_x2 VSS nfet_03v3 ad=0.65p pd=3.02u as=1.525p ps=6.22u w=2.5u l=0.5u
X239 VSS VSS a_13250_5878# VSS nfet_03v3 ad=3.05p pd=11.22u as=1.3p ps=5.52u w=5u l=1u
X240 a_14690_5774# a_14558_5878# a_13382_5774# VSS nfet_03v3 ad=1.3p pd=5.52u as=1.3p ps=5.52u w=5u l=2u
X241 a_3598_8020# voltage_reference_0.v_1_25 a_3619_2602# VSS nfet_03v3 ad=1.3p pd=5.52u as=1.3p ps=5.52u w=5u l=0.5u
X242 a_22199_13400# voltage_reference_0.v_1_15 voltage_reference_0.v_1_15 VDD pfet_03v3 ad=2.6p pd=10.52u as=2.6p ps=10.52u w=10u l=1u
X243 a_7657_6436# voltage_reference_0.v_1_25 a_8355_9194# VSS nfet_03v3 ad=1.3p pd=5.52u as=1.3p ps=5.52u w=5u l=0.5u
X244 a_7311_24128# a_11839_23276# VSS ppolyf_u_1k r_width=3u r_length=22u
X245 a_13492_1131# tanh_ota_0.V_ref a_13382_5774# VSS nfet_03v3 ad=1.3p pd=5.52u as=1.3p ps=5.52u w=5u l=2u
X246 tanh_ota_0.V_in_n tanh_ota_0.V_ref a_3415_6100# VSS nfet_03v3 ad=0.65p pd=3.02u as=0.65p ps=3.02u w=2.5u l=0.5u
X247 a_11555_17360# a_11555_17360# VSS VSS nfet_03v3 ad=0.39p pd=2.02u as=0.39p ps=2.02u w=1.5u l=0.5u
X248 a_8559_11644# tanh_ota_0.V_ref tanh_ota_0.V_in_n VSS nfet_03v3 ad=0.65p pd=3.02u as=0.65p ps=3.02u w=2.5u l=0.5u
X249 tanh_ota_0.V_ref a_13492_1131# VDD VSS nfet_03v3 ad=2.6p pd=10.52u as=2.6p ps=10.52u w=10u l=1u
X250 tanh_ota_0.V_in_n V_w2 a_3619_2602# VSS nfet_03v3 ad=0.65p pd=3.02u as=0.65p ps=3.02u w=2.5u l=0.5u
X251 VSS a_19458_8812# VSS ppolyf_u_1k r_width=3u r_length=30u
X252 VSS VSS a_7766_18788# VSS nfet_03v3 ad=3.05p pd=11.22u as=1.3p ps=5.52u w=5u l=0.5u
X253 VDD a_19458_12220# a_19458_12220# VDD pfet_03v3 ad=1.3p pd=5.52u as=1.3p ps=5.52u w=5u l=1u
X254 a_8559_11644# V_b tanh_ota_0.V_in_p VSS nfet_03v3 ad=0.65p pd=3.02u as=0.65p ps=3.02u w=2.5u l=0.5u
X255 a_8559_11644# V_b tanh_ota_0.V_in_p VSS nfet_03v3 ad=0.65p pd=3.02u as=0.65p ps=3.02u w=2.5u l=0.5u
X256 a_3619_2602# V_w2 tanh_ota_0.V_in_n VSS nfet_03v3 ad=0.65p pd=3.02u as=0.65p ps=3.02u w=2.5u l=0.5u
X257 VDD VDD a_14690_5774# VDD pfet_03v3 ad=6.5p pd=21.3u as=2.6p ps=10.52u w=10u l=2u
X258 a_14690_5774# VSS VSS VSS nfet_03v3 ad=1.3p pd=5.52u as=3.05p ps=11.22u w=5u l=2u
X259 a_3561_18262# a_2717_15824# VSS ppolyf_u_1k r_width=3u r_length=11.55u
X260 a_8559_11644# tanh_ota_0.V_ref tanh_ota_0.V_in_n VSS nfet_03v3 ad=0.65p pd=3.02u as=0.65p ps=3.02u w=2.5u l=0.5u
X261 voltage_reference_0.v_1_15 a_23777_13400# VSS VSS nfet_03v3 ad=1.3p pd=5.52u as=1.3p ps=5.52u w=5u l=1u
X262 a_3598_19300# tanh_ota_0.V_ref VSS VSS nfet_03v3 ad=1.04p pd=4.52u as=1.04p ps=4.52u w=4u l=1u
X263 VDD a_7766_18788# a_7766_18788# VDD pfet_03v3 ad=1.3p pd=5.52u as=1.3p ps=5.52u w=5u l=0.5u
X264 VDD a_14690_5774# a_13492_1131# VDD pfet_03v3 ad=2.6p pd=10.52u as=2.6p ps=10.52u w=10u l=2u
X265 tanh_ota_0.V_in_n tanh_ota_0.V_ref a_3415_6100# VSS nfet_03v3 ad=0.65p pd=3.02u as=0.65p ps=3.02u w=2.5u l=0.5u
X266 a_8501_6436# a_7657_3998# VSS ppolyf_u_1k r_width=3u r_length=11.55u
X267 VSS VSS tanh_ota_0.V_in_n VSS nfet_03v3 ad=1.525p pd=6.22u as=0.65p ps=3.02u w=2.5u l=0.5u
X268 a_14558_20330# a_19854_15770# VSS ppolyf_u_1k r_width=3u r_length=10u
X269 a_4405_12168# a_3561_9730# VSS ppolyf_u_1k r_width=3u r_length=11.55u
X270 a_9196_7474# voltage_reference_0.v_1_15 a_8559_11644# VSS nfet_03v3 ad=1.3p pd=5.52u as=1.3p ps=5.52u w=5u l=0.5u
X271 VDD a_14690_5774# a_14690_5774# VDD pfet_03v3 ad=2.6p pd=10.52u as=2.6p ps=10.52u w=10u l=2u
X272 a_19914_7960# a_26642_8812# VSS ppolyf_u_1k r_width=3u r_length=33u
X273 I_x1 voltage_reference_0.v_1_25 gilbert_multiplier_current_2.V_x_n VSS nfet_03v3 ad=1.525p pd=6.22u as=0.65p ps=3.02u w=2.5u l=0.5u
X274 tanh_ota_0.V_in_n tanh_ota_0.V_ref a_3415_21020# VSS nfet_03v3 ad=0.65p pd=3.02u as=0.65p ps=3.02u w=2.5u l=0.5u
X275 V_out_perceptron a_7766_18788# VDD VDD pfet_03v3 ad=1.3p pd=5.52u as=1.3p ps=5.52u w=5u l=0.5u
X276 a_14690_20226# a_14690_20226# VDD VDD pfet_03v3 ad=2.6p pd=10.52u as=2.6p ps=10.52u w=10u l=2u
X277 a_3619_2602# tanh_ota_0.V_ref tanh_ota_0.V_in_p VSS nfet_03v3 ad=0.65p pd=3.02u as=0.65p ps=3.02u w=2.5u l=0.5u
X278 tanh_ota_0.V_in_p V_w1 a_3415_21020# VSS nfet_03v3 ad=0.65p pd=3.02u as=0.65p ps=3.02u w=2.5u l=0.5u
X279 a_13382_20226# VSS VSS VSS nfet_03v3 ad=0.65p pd=3.02u as=1.525p ps=6.22u w=2.5u l=2u
X280 tanh_ota_0.V_ref a_13492_1131# VDD VSS nfet_03v3 ad=2.6p pd=10.52u as=2.6p ps=10.52u w=10u l=1u
X281 VSS VSS tanh_ota_0.V_in_n VSS nfet_03v3 ad=1.525p pd=6.22u as=0.65p ps=3.02u w=2.5u l=0.5u
X282 VSS VSS tanh_ota_0.V_in_n VSS nfet_03v3 ad=1.525p pd=6.22u as=0.65p ps=3.02u w=2.5u l=0.5u
X283 a_11555_17360# a_11555_17360# VSS VSS nfet_03v3 ad=0.39p pd=2.02u as=0.39p ps=2.02u w=1.5u l=0.5u
X284 a_11555_17360# a_11555_17360# VSS VSS nfet_03v3 ad=0.39p pd=2.02u as=0.39p ps=2.02u w=1.5u l=0.5u
X285 a_13492_24053# a_14690_20226# VDD VDD pfet_03v3 ad=2.6p pd=10.52u as=2.6p ps=10.52u w=10u l=2u
X286 gilbert_multiplier_current_2.V_x_n voltage_reference_0.v_1_25 VSS ppolyf_u_1k r_width=3u r_length=8.1u
X287 a_3415_6100# V_w2 tanh_ota_0.V_in_p VSS nfet_03v3 ad=0.65p pd=3.02u as=0.65p ps=3.02u w=2.5u l=0.5u
X288 a_9196_7474# tanh_ota_0.V_ref VSS VSS nfet_03v3 ad=1.04p pd=4.52u as=1.04p ps=4.52u w=4u l=1u
X289 VDD a_13492_24053# voltage_reference_0.v_1_25 VSS nfet_03v3 ad=2.6p pd=10.52u as=2.6p ps=10.52u w=10u l=1u
X290 a_10295_19296# tanh_ota_0.V_in_p a_7766_18788# VSS nfet_03v3 ad=1.3p pd=5.52u as=1.3p ps=5.52u w=5u l=0.5u
X291 a_2717_12168# a_3561_9730# VSS ppolyf_u_1k r_width=3u r_length=11.55u
X292 VSS tanh_ota_0.V_ref a_3598_8020# VSS nfet_03v3 ad=1.04p pd=4.52u as=1.04p ps=4.52u w=4u l=1u
X293 V_out_perceptron a_7766_18788# VDD VDD pfet_03v3 ad=1.3p pd=5.52u as=1.3p ps=5.52u w=5u l=0.5u
X294 a_14690_20226# VSS VSS VSS nfet_03v3 ad=1.3p pd=5.52u as=3.05p ps=11.22u w=5u l=2u
X295 gilbert_multiplier_current_1.V_x_n voltage_reference_0.v_1_25 VSS ppolyf_u_1k r_width=3u r_length=8.1u
X296 a_8559_11644# V_b tanh_ota_0.V_in_p VSS nfet_03v3 ad=0.65p pd=3.02u as=0.65p ps=3.02u w=2.5u l=0.5u
X297 VDD VDD a_23777_13400# VDD pfet_03v3 ad=6.5p pd=21.3u as=2.6p ps=10.52u w=10u l=1u
X298 a_9805_17650# a_8953_14522# VSS ppolyf_u_1k r_width=3u r_length=15u
X299 a_13330_16152# a_19458_17004# VSS ppolyf_u_1k r_width=3u r_length=30u
X300 a_8559_11644# tanh_ota_0.V_ref tanh_ota_0.V_in_n VSS nfet_03v3 ad=0.65p pd=3.02u as=0.65p ps=3.02u w=2.5u l=0.5u
X301 a_8355_9194# V_b tanh_ota_0.V_in_n VSS nfet_03v3 ad=0.65p pd=3.02u as=0.65p ps=3.02u w=2.5u l=0.5u
X302 a_23777_13400# VSS VSS VSS nfet_03v3 ad=1.3p pd=5.52u as=3.05p ps=11.22u w=5u l=1u
X303 VSS VSS a_3415_6100# VSS nfet_03v3 ad=3.05p pd=11.22u as=1.3p ps=5.52u w=5u l=0.5u
X304 a_8355_9194# tanh_ota_0.V_ref tanh_ota_0.V_in_p VSS nfet_03v3 ad=0.65p pd=3.02u as=0.65p ps=3.02u w=2.5u l=0.5u
X305 VSS VSS a_3619_22696# VSS nfet_03v3 ad=3.05p pd=11.22u as=1.3p ps=5.52u w=5u l=0.5u
X306 VDD VSS VSS VSS nfet_03v3 ad=2.6p pd=10.52u as=6.1p ps=21.22u w=10u l=1u
X307 a_3619_22696# tanh_ota_0.V_ref tanh_ota_0.V_in_p VSS nfet_03v3 ad=0.65p pd=3.02u as=0.65p ps=3.02u w=2.5u l=0.5u
X308 VSS VSS tanh_ota_0.V_in_p VSS nfet_03v3 ad=1.525p pd=6.22u as=0.65p ps=3.02u w=2.5u l=0.5u
X309 a_3619_22696# V_w1 tanh_ota_0.V_in_n VSS nfet_03v3 ad=0.65p pd=3.02u as=0.65p ps=3.02u w=2.5u l=0.5u
X310 VSS VSS VDD VSS nfet_03v3 ad=6.1p pd=21.22u as=2.6p ps=10.52u w=10u l=1u
X311 VSS VSS VSS VSS nfet_03v3 ad=0.915p pd=4.22u as=0 ps=0 w=1.5u l=0.5u
X312 a_14558_20330# a_19467_13334# VSS ppolyf_u_1k r_width=3u r_length=20u
X313 VSS VSS tanh_ota_0.V_in_p VSS nfet_03v3 ad=1.525p pd=6.22u as=0.65p ps=3.02u w=2.5u l=0.5u
X314 a_3598_19300# VSS VSS VSS nfet_03v3 ad=1.04p pd=4.52u as=2.44p ps=9.22u w=4u l=1u
X315 a_3619_2602# V_w2 tanh_ota_0.V_in_n VSS nfet_03v3 ad=0.65p pd=3.02u as=0.65p ps=3.02u w=2.5u l=0.5u
X316 voltage_reference_0.v_1_15 voltage_reference_0.v_1_15 a_22199_13400# VDD pfet_03v3 ad=2.6p pd=10.52u as=2.6p ps=10.52u w=10u l=1u
X317 a_14690_5774# a_14690_5774# VDD VDD pfet_03v3 ad=2.6p pd=10.52u as=2.6p ps=10.52u w=10u l=2u
X318 tanh_ota_0.V_in_p V_w2 a_3415_6100# VSS nfet_03v3 ad=0.65p pd=3.02u as=0.65p ps=3.02u w=2.5u l=0.5u
X319 VSS VSS a_7657_6436# VSS nfet_03v3 ad=2.44p pd=9.22u as=1.04p ps=4.52u w=4u l=1u
X320 VSS a_11555_17360# a_10295_19296# VSS nfet_03v3 ad=0.39p pd=2.02u as=0.39p ps=2.02u w=1.5u l=0.5u
X321 a_9196_7474# a_9345_3998# VSS ppolyf_u_1k r_width=3u r_length=11.55u
X322 VDD VDD a_19458_12220# VDD pfet_03v3 ad=3.25p pd=11.3u as=1.3p ps=5.52u w=5u l=1u
X323 a_4405_12168# a_3598_8020# VSS ppolyf_u_1k r_width=3u r_length=11.55u
X324 a_13492_1131# a_14690_5774# VDD VDD pfet_03v3 ad=2.6p pd=10.52u as=2.6p ps=10.52u w=10u l=2u
X325 a_8501_6436# a_9345_3998# VSS ppolyf_u_1k r_width=3u r_length=11.55u
X326 a_3619_2602# VSS VSS VSS nfet_03v3 ad=1.3p pd=5.52u as=3.05p ps=11.22u w=5u l=0.5u
X327 a_2717_18262# tanh_ota_0.V_ref VSS VSS nfet_03v3 ad=1.04p pd=4.52u as=1.04p ps=4.52u w=4u l=1u
X328 VSS VSS tanh_ota_0.V_in_p VSS nfet_03v3 ad=1.525p pd=6.22u as=0.65p ps=3.02u w=2.5u l=0.5u
X329 a_23777_13400# a_23777_13400# VSS VSS nfet_03v3 ad=1.3p pd=5.52u as=1.3p ps=5.52u w=5u l=1u
X330 a_13330_9664# a_19458_10516# VSS ppolyf_u_1k r_width=3u r_length=30u
X331 VSS tanh_ota_0.V_ref a_2717_9730# VSS nfet_03v3 ad=1.04p pd=4.52u as=1.04p ps=4.52u w=4u l=1u
X332 VSS VSS a_8355_9194# VSS nfet_03v3 ad=3.05p pd=11.22u as=1.3p ps=5.52u w=5u l=0.5u
X333 a_14690_5774# VDD VDD VDD pfet_03v3 ad=2.6p pd=10.52u as=6.5p ps=21.3u w=10u l=2u
X334 tanh_ota_0.V_ref a_13492_1131# VDD VSS nfet_03v3 ad=2.6p pd=10.52u as=2.6p ps=10.52u w=10u l=1u
X335 a_3619_2602# tanh_ota_0.V_ref tanh_ota_0.V_in_p VSS nfet_03v3 ad=0.65p pd=3.02u as=0.65p ps=3.02u w=2.5u l=0.5u
X336 VDD a_19458_12220# a_22199_13400# VDD pfet_03v3 ad=1.3p pd=5.52u as=1.3p ps=5.52u w=5u l=1u
X337 tanh_ota_0.V_ref VSS VSS ppolyf_u_1k r_width=3u r_length=20u
X338 a_3619_2602# tanh_ota_0.V_ref tanh_ota_0.V_in_p VSS nfet_03v3 ad=0.65p pd=3.02u as=0.65p ps=3.02u w=2.5u l=0.5u
X339 V_shift tanh_ota_0.V_in_p VSS ppolyf_u_1k r_width=3u r_length=7.3u
X340 tanh_ota_0.V_in_p V_b a_8559_11644# VSS nfet_03v3 ad=0.65p pd=3.02u as=0.65p ps=3.02u w=2.5u l=0.5u
C0 voltage_reference_0.v_1_25 a_2717_15824# 0.00402f
C1 a_3415_21020# a_3619_22696# 0.13501f
C2 a_19458_15300# a_19467_13334# 0.00264f
C3 voltage_reference_0.v_1_15 a_14558_5878# 0.08983f
C4 a_2717_18262# gilbert_multiplier_current_2.V_x_n 0.3651f
C5 V_b voltage_reference_0.v_1_25 0.16024f
C6 a_19458_8812# a_19458_10516# 0.0161f
C7 V_out_perceptron a_11839_24980# 0.00296f
C8 a_2717_18262# a_3619_22696# 0
C9 voltage_reference_0.v_1_15 tanh_ota_0.V_in_p 0
C10 V_out_perceptron a_13250_5878# 0.13171f
C11 I_x1 tanh_ota_0.V_in_p 0.12114f
C12 gilbert_multiplier_current_1.V_x_n tanh_ota_0.V_ref 0.03504f
C13 a_26642_10516# VDD 0.08026f
C14 voltage_reference_0.v_1_25 a_13382_20226# 1.04852f
C15 tanh_ota_0.V_ref gilbert_multiplier_current_2.V_x_n 0.02515f
C16 VDD a_19854_15770# 1.69864f
C17 a_3561_9730# tanh_ota_0.V_ref 0.03093f
C18 V_shift tanh_ota_0.V_in_n 0.03881f
C19 VDD voltage_reference_0.v_1_25 6.79869f
C20 VDD a_19458_10516# 0.07587f
C21 a_19914_9664# voltage_reference_0.v_1_15 0.0037f
C22 V_out_perceptron a_11839_23276# 0.00247f
C23 a_3619_2602# tanh_ota_0.V_in_n 2.37444f
C24 a_2717_9730# a_3598_8020# 0.23395f
C25 tanh_ota_0.V_ref a_3619_22696# 0.83293f
C26 a_3415_6100# tanh_ota_0.V_ref 0.75193f
C27 VDD a_19467_13334# 0.39186f
C28 tanh_ota_0.V_in_n a_9805_17650# 0
C29 V_out_perceptron a_10295_19296# 0.75246f
C30 a_8559_11644# voltage_reference_0.v_1_15 0.16229f
C31 V_out_perceptron a_13492_24053# 0.00194f
C32 a_2717_18262# a_3561_18262# 0.02724f
C33 a_13330_11368# a_13250_5878# 0.03052f
C34 a_13382_20226# a_11555_17360# 0
C35 a_2717_12168# tanh_ota_0.V_in_p 0.00686f
C36 a_19458_15300# a_19458_17004# 0.0161f
C37 I_x1 a_2717_15824# 0.00197f
C38 V_b voltage_reference_0.v_1_15 0.00333f
C39 a_3415_21020# tanh_ota_0.V_in_p 2.72648f
C40 I_x1 V_b 0.02978f
C41 voltage_reference_0.v_1_25 tanh_ota_0.V_in_n 1.18253f
C42 voltage_reference_0.v_1_15 a_19458_8812# 0.01849f
C43 voltage_reference_0.v_1_15 a_19914_7960# 0.03725f
C44 a_3598_19300# gilbert_multiplier_current_2.V_x_n 0.04166f
C45 a_11839_24980# a_11839_23276# 0.0161f
C46 a_2717_9730# gilbert_multiplier_current_1.V_x_n 0.3651f
C47 a_26642_16152# a_26642_17856# 0.0161f
C48 a_7657_6436# tanh_ota_0.V_in_n 0.17076f
C49 tanh_ota_0.V_in_p a_7766_18788# 0.36364f
C50 tanh_ota_0.V_ref a_3561_18262# 0.03093f
C51 a_19458_12220# a_19854_15770# 0.06245f
C52 a_19458_12220# a_19458_10516# 0.01841f
C53 a_9196_7474# voltage_reference_0.v_1_25 0
C54 a_2717_18262# tanh_ota_0.V_in_p 0.31773f
C55 V_shift voltage_reference_0.v_1_25 0.09992f
C56 a_3598_19300# a_3619_22696# 0.7754f
C57 a_3561_9730# a_2717_9730# 0.02724f
C58 a_11839_24980# a_13492_24053# 0.00339f
C59 a_13250_5878# a_10295_19296# 0
C60 V_w2 gilbert_multiplier_current_1.V_x_n 0.00333f
C61 a_13330_9664# a_13330_11368# 0.00587f
C62 I_x2 voltage_reference_0.v_1_25 0.20987f
C63 voltage_reference_0.v_1_25 a_3619_2602# 0.16254f
C64 a_13492_1131# a_14558_5878# 0.03312f
C65 tanh_ota_0.V_in_p a_8355_9194# 2.00137f
C66 a_7657_6436# a_9196_7474# 0.23395f
C67 tanh_ota_0.V_ref a_14558_5878# 1.47413f
C68 VDD voltage_reference_0.v_1_15 1.2947f
C69 a_19458_12220# a_19467_13334# 0.01424f
C70 a_13330_9664# a_13250_5878# 0.02924f
C71 V_w1 tanh_ota_0.V_in_n 1.32892f
C72 a_2717_9730# a_3415_6100# 0.77529f
C73 a_11555_17360# tanh_ota_0.V_in_n 0.01441f
C74 VDD a_19458_17004# 0.09195f
C75 a_13250_5878# a_14558_20330# 0.22359f
C76 a_13382_5774# voltage_reference_0.v_1_15 0.05166f
C77 tanh_ota_0.V_in_p tanh_ota_0.V_ref 5.95733f
C78 V_w2 a_3415_6100# 0.65431f
C79 gilbert_multiplier_current_1.V_x_n a_3598_8020# 0.04166f
C80 a_13492_24053# a_11839_23276# 0.00156f
C81 a_13382_20226# a_13330_17856# 0
C82 a_8559_11644# a_8355_9194# 0.13501f
C83 a_3561_9730# a_3598_8020# 0.02791f
C84 a_3598_19300# a_3561_18262# 0.02791f
C85 a_14690_5774# voltage_reference_0.v_1_15 0.05968f
C86 VDD a_22199_13400# 1.80269f
C87 a_11555_17360# a_9805_17650# 0.0059f
C88 a_8355_9194# a_8953_14522# 0.00419f
C89 a_7657_6436# voltage_reference_0.v_1_25 0.37895f
C90 a_19458_10516# a_19467_13334# 0
C91 a_3415_6100# a_3598_8020# 0
C92 a_8559_11644# tanh_ota_0.V_ref 0.98267f
C93 a_13492_24053# a_14558_20330# 0.03312f
C94 V_b a_8355_9194# 0.72896f
C95 tanh_ota_0.V_ref a_8953_14522# 0.02255f
C96 a_19458_12220# voltage_reference_0.v_1_15 0.01193f
C97 voltage_reference_0.v_1_15 a_9196_7474# 0.30482f
C98 V_out_perceptron tanh_ota_0.V_in_p 0.13196f
C99 V_w1 voltage_reference_0.v_1_25 0.00333f
C100 voltage_reference_0.v_1_25 a_11555_17360# 0.0254f
C101 tanh_ota_0.V_in_p a_3598_19300# 0.03585f
C102 gilbert_multiplier_current_1.V_x_n gilbert_multiplier_current_2.V_x_n 0
C103 V_b tanh_ota_0.V_ref 4.01697f
C104 VDD a_7766_18788# 7.56513f
C105 a_3561_9730# gilbert_multiplier_current_1.V_x_n 0
C106 a_2717_9730# tanh_ota_0.V_in_p 0.28218f
C107 a_3415_6100# gilbert_multiplier_current_1.V_x_n 0.16229f
C108 a_13330_11368# a_14558_5878# 0.0088f
C109 a_26642_10516# voltage_reference_0.v_1_15 0.02041f
C110 a_19854_15770# a_21914_17004# 0.0161f
C111 a_19458_12220# a_22199_13400# 0.65869f
C112 gilbert_multiplier_current_2.V_x_n a_3619_22696# 0
C113 V_w2 tanh_ota_0.V_in_p 1.12751f
C114 a_13250_5878# a_14558_5878# 0.215f
C115 a_3415_21020# tanh_ota_0.V_in_n 2.16944f
C116 voltage_reference_0.v_1_15 a_19854_15770# 0.17122f
C117 a_7311_22424# a_3619_22696# 0
C118 voltage_reference_0.v_1_15 voltage_reference_0.v_1_25 0.00769f
C119 V_out_perceptron a_8953_14522# 0
C120 a_13492_1131# VDD 3.92843f
C121 VDD tanh_ota_0.V_ref 6.5962f
C122 I_x1 voltage_reference_0.v_1_25 0.20987f
C123 a_13330_16152# a_11555_17360# 0
C124 voltage_reference_0.v_1_15 a_7657_6436# 0.03568f
C125 tanh_ota_0.V_in_n a_7766_18788# 0.47423f
C126 a_8501_6436# a_9196_7474# 0.02724f
C127 a_2717_12168# I_x2 0.00139f
C128 a_13382_5774# a_13492_1131# 0.2532f
C129 a_13382_5774# tanh_ota_0.V_ref 1.04852f
C130 a_13492_24053# a_14690_20226# 1.10709f
C131 a_8355_9194# tanh_ota_0.V_in_n 2.39106f
C132 tanh_ota_0.V_in_p a_4405_15824# 0.00777f
C133 V_shift a_7766_18788# 0.00117f
C134 a_22199_13400# a_19854_15770# 0.77357f
C135 a_13330_9664# a_14558_5878# 0.00953f
C136 a_14690_20226# a_14558_20330# 0.54051f
C137 a_3561_18262# gilbert_multiplier_current_2.V_x_n 0
C138 a_13492_1131# a_14690_5774# 1.10709f
C139 a_14690_5774# tanh_ota_0.V_ref 0.28006f
C140 tanh_ota_0.V_in_p a_10295_19296# 0.14065f
C141 a_9805_17650# a_7766_18788# 0.00182f
C142 a_14558_20330# a_14558_5878# 0.02642f
C143 a_9196_7474# a_8355_9194# 0
C144 V_out_perceptron a_13382_20226# 0.00195f
C145 tanh_ota_0.V_ref tanh_ota_0.V_in_n 6.49808f
C146 a_2717_12168# voltage_reference_0.v_1_25 0.0064f
C147 a_7311_24128# a_7311_22424# 0.0161f
C148 V_out_perceptron VDD 1.93991f
C149 VDD a_3598_19300# 0.00331f
C150 a_9345_3998# a_7657_3998# 0.01656f
C151 tanh_ota_0.V_in_p gilbert_multiplier_current_1.V_x_n 0.20574f
C152 a_9196_7474# tanh_ota_0.V_ref 0.46508f
C153 a_9345_3998# tanh_ota_0.V_ref 0.01755f
C154 a_8501_6436# a_7657_6436# 0.02791f
C155 a_11555_17360# a_13330_17856# 0.00441f
C156 tanh_ota_0.V_in_p gilbert_multiplier_current_2.V_x_n 0.25121f
C157 voltage_reference_0.v_1_25 a_7766_18788# 0
C158 a_3619_2602# tanh_ota_0.V_ref 0.92892f
C159 a_3561_9730# tanh_ota_0.V_in_p 0
C160 a_13330_16152# a_13330_17856# 0.00587f
C161 tanh_ota_0.V_in_p a_7311_22424# 0.00479f
C162 a_2717_15824# a_4405_15824# 0.01656f
C163 a_2717_18262# voltage_reference_0.v_1_25 0
C164 VDD a_26642_8812# 0.09804f
C165 tanh_ota_0.V_in_p a_3619_22696# 2.13719f
C166 a_3415_6100# tanh_ota_0.V_in_p 2.58652f
C167 voltage_reference_0.v_1_25 a_8355_9194# 0.16254f
C168 V_w1 a_3415_21020# 0.65271f
C169 VDD a_11839_24980# 0.0475f
C170 V_out_perceptron tanh_ota_0.V_in_n 0.51062f
C171 a_13382_20226# a_13250_5878# 0.70429f
C172 a_3598_19300# tanh_ota_0.V_in_n 0.10508f
C173 a_7657_6436# a_8355_9194# 0.77621f
C174 a_23777_13400# VDD 1.45789f
C175 voltage_reference_0.v_1_15 a_22199_13400# 1.5168f
C176 voltage_reference_0.v_1_25 tanh_ota_0.V_ref 1.59128f
C177 a_23777_13400# a_26642_16152# 0
C178 a_11555_17360# a_7766_18788# 0.03652f
C179 a_7657_6436# tanh_ota_0.V_ref 0.34683f
C180 V_b gilbert_multiplier_current_1.V_x_n 0.00705f
C181 a_13382_5774# a_13250_5878# 0.70424f
C182 a_2717_15824# gilbert_multiplier_current_2.V_x_n 0.05207f
C183 VDD a_11839_23276# 0
C184 V_out_perceptron a_9805_17650# 0.06311f
C185 V_b gilbert_multiplier_current_2.V_x_n 0
C186 V_w2 tanh_ota_0.V_in_n 1.33403f
C187 tanh_ota_0.V_in_p a_3561_18262# 0
C188 a_13492_24053# a_13382_20226# 0.2532f
C189 a_2717_9730# a_3619_2602# 0
C190 V_w1 tanh_ota_0.V_ref 3.92601f
C191 VDD a_13492_24053# 4.32068f
C192 a_13382_20226# a_14558_20330# 0.55712f
C193 V_w2 a_3619_2602# 0.71689f
C194 VDD a_14558_20330# 0.09051f
C195 a_3598_8020# tanh_ota_0.V_in_n 0.03112f
C196 V_out_perceptron voltage_reference_0.v_1_25 0.09239f
C197 voltage_reference_0.v_1_25 a_3598_19300# 0.61396f
C198 voltage_reference_0.v_1_15 a_8355_9194# 0
C199 tanh_ota_0.V_in_n a_4405_15824# 0
C200 a_19914_9664# a_14558_5878# 0.0161f
C201 VDD a_7311_22424# 0.23421f
C202 a_26642_10516# a_26642_8812# 0.0161f
C203 a_2717_9730# voltage_reference_0.v_1_25 0
C204 a_4405_12168# voltage_reference_0.v_1_25 0.02497f
C205 tanh_ota_0.V_in_n a_10295_19296# 0.17229f
C206 VDD a_3619_22696# 0.00546f
C207 voltage_reference_0.v_1_15 tanh_ota_0.V_ref 0.14918f
C208 a_3598_8020# a_3619_2602# 0.77598f
C209 V_w2 voltage_reference_0.v_1_25 0.00333f
C210 a_26642_10516# a_23777_13400# 0
C211 V_out_perceptron a_11555_17360# 0.03103f
C212 V_out_perceptron a_13330_16152# 0.00214f
C213 a_8559_11644# tanh_ota_0.V_in_p 2.58855f
C214 a_23777_13400# a_19854_15770# 0.62866f
C215 a_9805_17650# a_10295_19296# 0
C216 tanh_ota_0.V_in_p a_8953_14522# 0.08037f
C217 a_3415_21020# a_2717_18262# 0.77452f
C218 voltage_reference_0.v_1_25 a_13250_5878# 0.07725f
C219 tanh_ota_0.V_in_n a_7311_22424# 0.01732f
C220 tanh_ota_0.V_in_p a_2717_15824# 0.01311f
C221 a_3598_8020# voltage_reference_0.v_1_25 0.72971f
C222 tanh_ota_0.V_in_n a_3619_22696# 2.37371f
C223 V_b tanh_ota_0.V_in_p 2.43096f
C224 I_x2 gilbert_multiplier_current_1.V_x_n 0.52208f
C225 a_3415_6100# tanh_ota_0.V_in_n 2.16944f
C226 a_21914_17004# a_21914_18708# 0.0161f
C227 voltage_reference_0.v_1_25 a_4405_15824# 0.02497f
C228 gilbert_multiplier_current_1.V_x_n a_3619_2602# 0
C229 a_14690_20226# a_13382_20226# 0.41277f
C230 voltage_reference_0.v_1_25 a_11839_23276# 0.05065f
C231 VDD a_7311_24128# 0.2502f
C232 VDD a_14690_20226# 6.6799f
C233 a_8501_6436# tanh_ota_0.V_ref 0.03259f
C234 a_3415_21020# tanh_ota_0.V_ref 0.7469f
C235 VDD a_14558_5878# 0.07822f
C236 a_11555_17360# a_13250_5878# 0.22118f
C237 a_13492_24053# voltage_reference_0.v_1_25 3.7839f
C238 a_3415_6100# a_3619_2602# 0.13501f
C239 a_19914_9664# a_19458_8812# 0.08585f
C240 a_19914_9664# a_19914_7960# 0.0161f
C241 a_13330_16152# a_13250_5878# 0.03953f
C242 tanh_ota_0.V_ref a_7766_18788# 0.06904f
C243 a_13382_5774# a_14558_5878# 0.55708f
C244 a_8559_11644# V_b 0.65271f
C245 VDD tanh_ota_0.V_in_p 0.11052f
C246 voltage_reference_0.v_1_25 a_14558_20330# 1.47413f
C247 voltage_reference_0.v_1_15 a_26642_8812# 0.02284f
C248 gilbert_multiplier_current_1.V_x_n voltage_reference_0.v_1_25 0.21459f
C249 a_2717_18262# tanh_ota_0.V_ref 0.26229f
C250 V_out_perceptron a_13330_17856# 0.00168f
C251 V_b a_8953_14522# 0.01286f
C252 voltage_reference_0.v_1_25 gilbert_multiplier_current_2.V_x_n 0.21462f
C253 a_11555_17360# a_11839_23276# 0.0161f
C254 tanh_ota_0.V_ref a_8355_9194# 0.88892f
C255 a_3561_9730# voltage_reference_0.v_1_25 0
C256 a_7311_24128# tanh_ota_0.V_in_n 0.00281f
C257 a_11555_17360# a_10295_19296# 0.17848f
C258 voltage_reference_0.v_1_25 a_7311_22424# 0.10628f
C259 a_14690_5774# a_14558_5878# 0.54051f
C260 a_19914_9664# VDD 0.01292f
C261 a_23777_13400# voltage_reference_0.v_1_15 0.84737f
C262 tanh_ota_0.V_ref a_7657_3998# 0.01755f
C263 voltage_reference_0.v_1_15 a_13250_5878# 0.08069f
C264 voltage_reference_0.v_1_25 a_3619_22696# 0.35627f
C265 a_13492_1131# tanh_ota_0.V_ref 3.7839f
C266 a_3415_21020# a_3598_19300# 0
C267 a_19458_8812# a_19914_7960# 0.08585f
C268 VDD a_19458_15300# 0.0951f
C269 a_2717_12168# a_4405_12168# 0.01656f
C270 a_19458_12220# a_14558_5878# 0.03563f
C271 V_w1 gilbert_multiplier_current_2.V_x_n 0.00333f
C272 tanh_ota_0.V_in_p tanh_ota_0.V_in_n 8.79808f
C273 a_13330_16152# a_14558_20330# 0.0074f
C274 V_out_perceptron a_7766_18788# 2.12528f
C275 a_2717_18262# a_3598_19300# 0.23395f
C276 a_23777_13400# a_22199_13400# 0.99499f
C277 a_13330_17856# a_13250_5878# 0.02924f
C278 V_w1 a_3619_22696# 0.71915f
C279 tanh_ota_0.V_in_p a_9196_7474# 0
C280 V_shift tanh_ota_0.V_in_p 0.04934f
C281 a_13330_9664# voltage_reference_0.v_1_15 0.0037f
C282 VDD a_19458_8812# 0.07538f
C283 a_21914_17004# a_14558_20330# 0.00325f
C284 VDD a_19914_7960# 0.0373f
C285 I_x2 tanh_ota_0.V_in_p 0.08148f
C286 tanh_ota_0.V_in_p a_3619_2602# 1.99792f
C287 voltage_reference_0.v_1_25 a_3561_18262# 0
C288 tanh_ota_0.V_in_p a_9805_17650# 0.0388f
C289 a_8559_11644# tanh_ota_0.V_in_n 2.16944f
C290 a_7311_24128# voltage_reference_0.v_1_25 0.00294f
C291 voltage_reference_0.v_1_25 a_14690_20226# 0.2801f
C292 V_out_perceptron tanh_ota_0.V_ref 0
C293 a_19458_17004# a_14558_20330# 0.08837f
C294 tanh_ota_0.V_in_n a_8953_14522# 0.0011f
C295 a_3598_19300# tanh_ota_0.V_ref 0.45119f
C296 VDD a_13382_20226# 0.00179f
C297 I_x1 gilbert_multiplier_current_2.V_x_n 0.52208f
C298 a_19458_10516# a_14558_5878# 0.15325f
C299 a_8559_11644# a_9196_7474# 0.77508f
C300 a_2717_9730# tanh_ota_0.V_ref 0.26733f
C301 a_4405_12168# tanh_ota_0.V_ref 0.00372f
C302 V_b tanh_ota_0.V_in_n 1.55496f
C303 tanh_ota_0.V_in_p voltage_reference_0.v_1_25 0.44798f
C304 a_13330_17856# a_14558_20330# 0.01007f
C305 a_13382_5774# VDD 0.00179f
C306 V_w2 tanh_ota_0.V_ref 3.92601f
C307 a_19914_9664# a_19458_10516# 0.08585f
C308 a_2717_12168# gilbert_multiplier_current_1.V_x_n 0.05238f
C309 I_x2 V_b 0.04147f
C310 a_10295_19296# a_7766_18788# 1.10067f
C311 VDD a_14690_5774# 6.6799f
C312 tanh_ota_0.V_ref a_13250_5878# 0.39048f
C313 VDD tanh_ota_0.V_in_n 1.16046f
C314 a_3415_21020# gilbert_multiplier_current_2.V_x_n 0.16229f
C315 V_w1 tanh_ota_0.V_in_p 1.09485f
C316 a_3598_8020# tanh_ota_0.V_ref 0.46973f
C317 a_19458_15300# a_19854_15770# 0.02115f
C318 tanh_ota_0.V_in_p a_11555_17360# 0.12224f
C319 a_13382_5774# a_14690_5774# 0.41277f
C320 tanh_ota_0.V_ref a_4405_15824# 0.00372f
C321 a_8559_11644# a_7657_6436# 0
C322 a_19458_12220# VDD 6.14308f
C323 V_shift VDD 0.05962f
C324 V_w2 VSS 5.55842f
C325 V_b VSS 5.98891f
C326 I_x2 VSS 2.15596f
C327 I_x1 VSS 2.15596f
C328 V_out_perceptron VSS 9.29739f
C329 V_shift VSS 3.51214f
C330 V_w1 VSS 5.36761f
C331 VDD VSS 0.14804p
C332 a_13492_1131# VSS 6.90433f
C333 a_14690_5774# VSS 1.43767f
C334 a_13382_5774# VSS 1.63765f
C335 a_9345_3998# VSS 1.3734f
C336 a_8501_6436# VSS 1.59945f
C337 a_7657_3998# VSS 1.37744f
C338 a_3619_2602# VSS 3.2564f
C339 a_3415_6100# VSS 2.66531f
C340 a_19914_7960# VSS 1.26323f
C341 a_26642_8812# VSS 1.52344f
C342 a_19458_8812# VSS 1.15657f
C343 a_9196_7474# VSS 2.86328f
C344 a_7657_6436# VSS 3.44657f
C345 a_3598_8020# VSS 3.30825f
C346 a_19914_9664# VSS 1.22088f
C347 a_13330_9664# VSS 1.66578f
C348 a_26642_10516# VSS 1.64278f
C349 a_19458_10516# VSS 1.25524f
C350 a_13330_11368# VSS 1.67099f
C351 voltage_reference_0.v_1_15 VSS 8.23164f
C352 a_23777_13400# VSS 4.54862f
C353 a_22199_13400# VSS 0.12817f
C354 a_8559_11644# VSS 2.47344f
C355 a_4405_12168# VSS 1.36843f
C356 a_3561_9730# VSS 1.59921f
C357 a_2717_9730# VSS 2.68403f
C358 a_2717_12168# VSS 1.42226f
C359 a_19458_12220# VSS 1.70911f
C360 a_14558_5878# VSS 9.00053f
C361 a_19467_13334# VSS 1.06213f
C362 a_8355_9194# VSS 3.16083f
C363 gilbert_multiplier_current_1.V_x_n VSS 5.12409f
C364 a_19854_15770# VSS 3.18764f
C365 a_26642_16152# VSS 1.72144f
C366 a_19458_15300# VSS 1.30485f
C367 a_13330_16152# VSS 1.80316f
C368 a_21914_17004# VSS 1.38373f
C369 a_19458_17004# VSS 1.29609f
C370 a_26642_17856# VSS 1.61377f
C371 a_13330_17856# VSS 1.65403f
C372 a_21914_18708# VSS 1.37777f
C373 a_14558_20330# VSS 9.0181f
C374 a_14690_20226# VSS 1.43767f
C375 a_13250_5878# VSS 17.2623f
C376 a_13382_20226# VSS 1.68973f
C377 a_9805_17650# VSS 1.58768f
C378 a_8953_14522# VSS 1.38267f
C379 a_10295_19296# VSS 0.59657f
C380 a_7766_18788# VSS 1.44377f
C381 a_4405_15824# VSS 1.36822f
C382 a_3561_18262# VSS 1.59946f
C383 a_2717_15824# VSS 1.43413f
C384 a_3598_19300# VSS 3.32452f
C385 a_2717_18262# VSS 2.6771f
C386 gilbert_multiplier_current_2.V_x_n VSS 5.12717f
C387 a_11555_17360# VSS 12.766f
C388 voltage_reference_0.v_1_25 VSS 21.9821f
C389 a_13492_24053# VSS 6.85617f
C390 a_7311_22424# VSS 1.21892f
C391 a_11839_23276# VSS 1.59488f
C392 a_3415_21020# VSS 2.66531f
C393 a_7311_24128# VSS 1.20881f
C394 tanh_ota_0.V_in_p VSS 18.4344f
C395 a_3619_22696# VSS 3.1909f
C396 tanh_ota_0.V_in_n VSS 12.9603f
C397 tanh_ota_0.V_ref VSS 46.3341f
C398 a_11839_24980# VSS 1.60478f
.ends perceptron_core_pex_c
