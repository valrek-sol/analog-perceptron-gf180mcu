* perceptron_pex_c — Magic C extraction of perceptron (gds/perceptron.gds)
* generated by pex/pex.tcl, see pex/out/env.txt for provenance
* ports (schematic order): VDD V_shift V_w1 I_x1 V_out_perceptron V_b I_x2 V_w2 VSS
* NGSPICE file created from perceptron.ext - technology: gf180mcuD

.subckt perceptron_pex_c VDD V_shift V_w1 I_x1 V_out_perceptron V_b I_x2 V_w2 VSS
X0 VSS VSS VSS VSS nfet_03v3 ad=0.915p pd=4.22u as=0.18551n ps=0.72964m w=1.5u l=0.5u
D0 VSS I_x1_core diode_nd2ps_06v0 pj=40u area=99.99999p
D1 VSS V_w2_core diode_nd2ps_06v0 pj=40u area=99.99999p
X1 a_49135_56824# perceptron_core_0.tanh_ota_0.V_ref perceptron_core_0.tanh_ota_0.V_in_n VSS nfet_03v3 ad=0.65p pd=3.02u as=0.65p ps=3.02u w=2.5u l=0.5u
X2 a_50871_64476# a_52131_62540# VSS VSS nfet_03v3 ad=0.39p pd=2.02u as=0.39p ps=2.02u w=1.5u l=0.5u
X3 a_49135_56824# perceptron_core_0.voltage_reference_0.v_1_15 a_49772_52654# VSS nfet_03v3 ad=1.3p pd=5.52u as=1.3p ps=5.52u w=5u l=0.5u
X4 a_49135_56824# V_b_core perceptron_core_0.tanh_ota_0.V_in_p VSS nfet_03v3 ad=0.65p pd=3.02u as=0.65p ps=3.02u w=2.5u l=0.5u
X5 perceptron_core_0.gilbert_multiplier_current_2.V_x_n perceptron_core_0.voltage_reference_0.v_1_25 I_x1_core VSS nfet_03v3 ad=0.65p pd=3.02u as=1.525p ps=6.22u w=2.5u l=0.5u
X6 a_62490_62184# a_67218_61332# VSS ppolyf_u_1k r_width=3u r_length=23u
X7 a_49135_56824# VSS VSS VSS nfet_03v3 ad=1.3p pd=5.52u as=3.05p ps=11.22u w=5u l=0.5u
X8 a_49135_56824# perceptron_core_0.tanh_ota_0.V_ref perceptron_core_0.tanh_ota_0.V_in_n VSS nfet_03v3 ad=0.65p pd=3.02u as=0.65p ps=3.02u w=2.5u l=0.5u
X9 a_53906_61332# a_60034_62184# VSS ppolyf_u_1k r_width=3u r_length=30u
D2 VSS I_x1_core diode_nd2ps_06v0 pj=40u area=99.99999p
X10 perceptron_core_0.voltage_reference_0.v_1_25 a_54068_69233# VDD VSS nfet_03v3 ad=2.6p pd=10.52u as=2.6p ps=10.52u w=10u l=1u
X11 perceptron_core_0.tanh_ota_0.V_in_p V_b_core a_49135_56824# VSS nfet_03v3 ad=0.65p pd=3.02u as=0.65p ps=3.02u w=2.5u l=0.5u
D3 I_x2_core VDD diode_pd2nw_06v0 pj=40u area=99.99999p
X12 a_55266_65406# a_55134_65510# a_53958_65406# VSS nfet_03v3 ad=1.3p pd=5.52u as=1.3p ps=5.52u w=5u l=2u
X13 perceptron_core_0.tanh_ota_0.V_in_n perceptron_core_0.tanh_ota_0.V_ref a_49135_56824# VSS nfet_03v3 ad=0.65p pd=3.02u as=0.65p ps=3.02u w=2.5u l=0.5u
X14 VDD VDD a_55266_65406# VDD pfet_03v3 ad=6.5p pd=21.3u as=2.6p ps=10.52u w=10u l=2u
X15 VSS a_52131_62540# a_52131_62540# VSS nfet_03v3 ad=0.39p pd=2.02u as=0.39p ps=2.02u w=1.5u l=0.5u
D4 VSS V_shift_core diode_nd2ps_06v0 pj=40u area=99.99999p
D5 V_shift_core VDD diode_pd2nw_06v0 pj=40u area=99.99999p
X16 VDD a_54068_69233# perceptron_core_0.voltage_reference_0.v_1_25 VSS nfet_03v3 ad=2.6p pd=10.52u as=2.6p ps=10.52u w=10u l=1u
X17 VSS perceptron_core_0.tanh_ota_0.V_ref a_48233_51616# VSS nfet_03v3 ad=1.04p pd=4.52u as=1.04p ps=4.52u w=4u l=1u
X18 VDD a_54068_46311# perceptron_core_0.tanh_ota_0.V_ref VSS nfet_03v3 ad=2.6p pd=10.52u as=2.6p ps=10.52u w=10u l=1u
X19 VDD a_48342_63968# a_48342_63968# VDD pfet_03v3 ad=1.3p pd=5.52u as=1.3p ps=5.52u w=5u l=0.5u
X20 a_53906_56548# a_60034_55696# VSS ppolyf_u_1k r_width=3u r_length=30u
X21 a_54068_69233# perceptron_core_0.voltage_reference_0.v_1_25 a_53958_65406# VSS nfet_03v3 ad=1.3p pd=5.52u as=1.3p ps=5.52u w=5u l=2u
X22 VSS VSS perceptron_core_0.tanh_ota_0.V_in_n VSS nfet_03v3 ad=1.525p pd=6.22u as=0.65p ps=3.02u w=2.5u l=0.5u
D6 V_w1_core VDD diode_pd2nw_06v0 pj=40u area=99.99999p
X23 perceptron_core_0.tanh_ota_0.V_in_p V_w2_core a_43991_51280# VSS nfet_03v3 ad=0.65p pd=3.02u as=0.65p ps=3.02u w=2.5u l=0.5u
X24 VSS VSS a_64353_58580# VSS nfet_03v3 ad=3.05p pd=11.22u as=1.3p ps=5.52u w=5u l=1u
X25 VDD a_55266_65406# a_54068_69233# VDD pfet_03v3 ad=2.6p pd=10.52u as=2.6p ps=10.52u w=10u l=2u
X26 VSS VSS VDD VSS nfet_03v3 ad=6.1p pd=21.22u as=2.6p ps=10.52u w=10u l=1u
X27 a_44195_67876# perceptron_core_0.tanh_ota_0.V_ref perceptron_core_0.tanh_ota_0.V_in_p VSS nfet_03v3 ad=0.65p pd=3.02u as=0.65p ps=3.02u w=2.5u l=0.5u
X28 perceptron_core_0.tanh_ota_0.V_in_n V_w2_core a_44195_47782# VSS nfet_03v3 ad=0.65p pd=3.02u as=0.65p ps=3.02u w=2.5u l=0.5u
X29 perceptron_core_0.tanh_ota_0.V_in_n perceptron_core_0.tanh_ota_0.V_ref a_43991_66200# VSS nfet_03v3 ad=0.65p pd=3.02u as=0.65p ps=3.02u w=2.5u l=0.5u
X30 perceptron_core_0.tanh_ota_0.V_in_p perceptron_core_0.tanh_ota_0.V_ref a_44195_47782# VSS nfet_03v3 ad=0.65p pd=3.02u as=0.65p ps=3.02u w=2.5u l=0.5u
X31 a_55266_65406# VSS VSS VSS nfet_03v3 ad=1.3p pd=5.52u as=3.05p ps=11.22u w=5u l=2u
X32 VDD VSS VSS VSS nfet_03v3 ad=2.6p pd=10.52u as=6.1p ps=21.22u w=10u l=1u
X33 perceptron_core_0.tanh_ota_0.V_in_n perceptron_core_0.tanh_ota_0.V_ref a_43991_51280# VSS nfet_03v3 ad=0.65p pd=3.02u as=0.65p ps=3.02u w=2.5u l=0.5u
X34 a_53958_65406# a_53826_51058# VSS VSS nfet_03v3 ad=0.65p pd=3.02u as=0.65p ps=3.02u w=2.5u l=2u
X35 VSS VSS a_48931_54374# VSS nfet_03v3 ad=3.05p pd=11.22u as=1.3p ps=5.52u w=5u l=0.5u
X36 a_55134_51058# a_67218_55696# VSS ppolyf_u_1k r_width=3u r_length=33u
X37 perceptron_core_0.tanh_ota_0.V_in_p V_w2_core a_43991_51280# VSS nfet_03v3 ad=0.65p pd=3.02u as=0.65p ps=3.02u w=2.5u l=0.5u
X38 V_w2 V_w2_core VDD ppolyf_u r_width=40u r_length=10u
X39 VSS a_53826_51058# a_53826_51058# VSS nfet_03v3 ad=1.3p pd=5.52u as=1.3p ps=5.52u w=5u l=1u
X40 a_48233_51616# perceptron_core_0.voltage_reference_0.v_1_25 a_48931_54374# VSS nfet_03v3 ad=1.3p pd=5.52u as=1.3p ps=5.52u w=5u l=0.5u
X41 VSS VSS perceptron_core_0.tanh_ota_0.V_in_p VSS nfet_03v3 ad=1.525p pd=6.22u as=0.65p ps=3.02u w=2.5u l=0.5u
X42 VSS perceptron_core_0.tanh_ota_0.V_ref a_43293_54910# VSS nfet_03v3 ad=1.04p pd=4.52u as=1.04p ps=4.52u w=4u l=1u
X43 a_49135_56824# V_b_core perceptron_core_0.tanh_ota_0.V_in_p VSS nfet_03v3 ad=0.65p pd=3.02u as=0.65p ps=3.02u w=2.5u l=0.5u
X44 V_shift V_shift_core VDD ppolyf_u r_width=40u r_length=10u
X45 perceptron_core_0.tanh_ota_0.V_in_n VSS VSS VSS nfet_03v3 ad=0.65p pd=3.02u as=1.525p ps=6.22u w=2.5u l=0.5u
X46 a_43991_51280# V_w2_core perceptron_core_0.tanh_ota_0.V_in_p VSS nfet_03v3 ad=0.65p pd=3.02u as=0.65p ps=3.02u w=2.5u l=0.5u
X47 perceptron_core_0.tanh_ota_0.V_ref a_54068_46311# VDD VSS nfet_03v3 ad=2.6p pd=10.52u as=2.6p ps=10.52u w=10u l=1u
X48 a_53958_65406# a_53826_51058# VSS VSS nfet_03v3 ad=0.65p pd=3.02u as=0.65p ps=3.02u w=2.5u l=2u
X49 a_44195_47782# V_w2_core perceptron_core_0.tanh_ota_0.V_in_n VSS nfet_03v3 ad=0.65p pd=3.02u as=0.65p ps=3.02u w=2.5u l=0.5u
X50 a_62775_58580# a_60430_60950# a_64353_58580# VDD pfet_03v3 ad=2.6p pd=10.52u as=2.6p ps=10.52u w=10u l=1u
X51 a_49135_56824# perceptron_core_0.tanh_ota_0.V_ref perceptron_core_0.tanh_ota_0.V_in_n VSS nfet_03v3 ad=0.65p pd=3.02u as=0.65p ps=3.02u w=2.5u l=0.5u
X52 a_50381_62830# a_49529_59702# VSS ppolyf_u_1k r_width=3u r_length=15u
X53 VSS a_52131_62540# a_52131_62540# VSS nfet_03v3 ad=0.39p pd=2.02u as=0.39p ps=2.02u w=1.5u l=0.5u
X54 a_48342_63968# VSS VSS VSS nfet_03v3 ad=1.3p pd=5.52u as=3.05p ps=11.22u w=5u l=0.5u
X55 perceptron_core_0.tanh_ota_0.V_in_p perceptron_core_0.tanh_ota_0.V_ref a_48931_54374# VSS nfet_03v3 ad=0.65p pd=3.02u as=0.65p ps=3.02u w=2.5u l=0.5u
X56 a_49135_56824# V_b_core perceptron_core_0.tanh_ota_0.V_in_p VSS nfet_03v3 ad=0.65p pd=3.02u as=0.65p ps=3.02u w=2.5u l=0.5u
X57 a_43991_66200# perceptron_core_0.tanh_ota_0.V_ref perceptron_core_0.tanh_ota_0.V_in_n VSS nfet_03v3 ad=0.65p pd=3.02u as=0.65p ps=3.02u w=2.5u l=0.5u
X58 a_43991_51280# perceptron_core_0.gilbert_multiplier_current_1.V_x_n a_43293_54910# VSS nfet_03v3 ad=1.3p pd=5.52u as=1.3p ps=5.52u w=5u l=0.5u
X59 perceptron_core_0.tanh_ota_0.V_in_n V_b_core a_48931_54374# VSS nfet_03v3 ad=0.65p pd=3.02u as=0.65p ps=3.02u w=2.5u l=0.5u
X60 a_53958_65406# VSS VSS VSS nfet_03v3 ad=0.65p pd=3.02u as=1.525p ps=6.22u w=2.5u l=2u
X61 VSS a_52131_62540# a_52131_62540# VSS nfet_03v3 ad=0.39p pd=2.02u as=0.39p ps=2.02u w=1.5u l=0.5u
D7 VSS V_out_perceptron_core diode_nd2ps_06v0 pj=40u area=99.99999p
X62 VSS a_64353_58580# perceptron_core_0.voltage_reference_0.v_1_15 VSS nfet_03v3 ad=1.3p pd=5.52u as=1.3p ps=5.52u w=5u l=1u
X63 a_62775_58580# a_60034_57400# VDD VDD pfet_03v3 ad=1.3p pd=5.52u as=1.3p ps=5.52u w=5u l=1u
X64 VSS VSS a_55266_50954# VSS nfet_03v3 ad=3.05p pd=11.22u as=1.3p ps=5.52u w=5u l=2u
D8 VSS I_x1_core diode_nd2ps_06v0 pj=40u area=99.99999p
D9 V_w1_core VDD diode_pd2nw_06v0 pj=40u area=99.99999p
X65 perceptron_core_0.tanh_ota_0.V_in_p VSS VSS VSS nfet_03v3 ad=0.65p pd=3.02u as=1.525p ps=6.22u w=2.5u l=0.5u
X66 a_60034_57400# a_60034_57400# VDD VDD pfet_03v3 ad=1.3p pd=5.52u as=1.3p ps=5.52u w=5u l=1u
X67 a_55134_65510# a_60430_60950# VSS ppolyf_u_1k r_width=3u r_length=10u
X68 a_53958_50954# perceptron_core_0.tanh_ota_0.V_ref a_54068_46311# VSS nfet_03v3 ad=1.3p pd=5.52u as=1.3p ps=5.52u w=5u l=2u
X69 VSS perceptron_core_0.tanh_ota_0.V_ref a_43293_63442# VSS nfet_03v3 ad=1.04p pd=4.52u as=1.04p ps=4.52u w=4u l=1u
D10 V_b_core VDD diode_pd2nw_06v0 pj=40u area=99.99999p
X70 VDD a_54068_46311# perceptron_core_0.tanh_ota_0.V_ref VSS nfet_03v3 ad=2.6p pd=10.52u as=2.6p ps=10.52u w=10u l=1u
X71 a_62490_63888# a_67218_63036# VSS ppolyf_u_1k r_width=3u r_length=23u
D11 VSS V_out_perceptron_core diode_nd2ps_06v0 pj=40u area=99.99999p
X72 a_53958_50954# a_55134_51058# a_55266_50954# VSS nfet_03v3 ad=1.3p pd=5.52u as=1.3p ps=5.52u w=5u l=2u
X73 perceptron_core_0.tanh_ota_0.V_in_n V_b_core a_48931_54374# VSS nfet_03v3 ad=0.65p pd=3.02u as=0.65p ps=3.02u w=2.5u l=0.5u
X74 a_53906_63036# VDD VSS ppolyf_u_1k r_width=3u r_length=30u
X75 a_48931_54374# perceptron_core_0.tanh_ota_0.V_ref perceptron_core_0.tanh_ota_0.V_in_p VSS nfet_03v3 ad=0.65p pd=3.02u as=0.65p ps=3.02u w=2.5u l=0.5u
X76 a_53958_65406# a_55134_65510# a_55266_65406# VSS nfet_03v3 ad=1.3p pd=5.52u as=1.3p ps=5.52u w=5u l=2u
X77 VSS VSS a_53958_50954# VSS nfet_03v3 ad=1.525p pd=6.22u as=0.65p ps=3.02u w=2.5u l=2u
D12 V_w2_core VDD diode_pd2nw_06v0 pj=40u area=99.99999p
X78 perceptron_core_0.tanh_ota_0.V_in_p perceptron_core_0.tanh_ota_0.V_ref a_48931_54374# VSS nfet_03v3 ad=0.65p pd=3.02u as=0.65p ps=3.02u w=2.5u l=0.5u
X79 perceptron_core_0.tanh_ota_0.V_in_n V_w2_core a_44195_47782# VSS nfet_03v3 ad=0.65p pd=3.02u as=0.65p ps=3.02u w=2.5u l=0.5u
X80 a_48931_54374# V_b_core perceptron_core_0.tanh_ota_0.V_in_n VSS nfet_03v3 ad=0.65p pd=3.02u as=0.65p ps=3.02u w=2.5u l=0.5u
X81 VSS a_52131_62540# a_52131_62540# VSS nfet_03v3 ad=0.39p pd=2.02u as=0.39p ps=2.02u w=1.5u l=0.5u
X82 a_48931_54374# perceptron_core_0.tanh_ota_0.V_ref perceptron_core_0.tanh_ota_0.V_in_p VSS nfet_03v3 ad=0.65p pd=3.02u as=0.65p ps=3.02u w=2.5u l=0.5u
X83 VDD a_54068_69233# perceptron_core_0.voltage_reference_0.v_1_25 VSS nfet_03v3 ad=2.6p pd=10.52u as=2.6p ps=10.52u w=10u l=1u
D13 V_b_core VDD diode_pd2nw_06v0 pj=40u area=99.99999p
X84 perceptron_core_0.tanh_ota_0.V_in_n perceptron_core_0.tanh_ota_0.V_ref a_43991_51280# VSS nfet_03v3 ad=0.65p pd=3.02u as=0.65p ps=3.02u w=2.5u l=0.5u
X85 VSS a_53826_51058# a_53958_50954# VSS nfet_03v3 ad=0.65p pd=3.02u as=0.65p ps=3.02u w=2.5u l=2u
X86 perceptron_core_0.tanh_ota_0.V_ref VSS VSS ppolyf_u_1k r_width=3u r_length=20u
D14 VSS V_b_core diode_nd2ps_06v0 pj=40u area=99.99999p
X87 a_52131_62540# a_52131_62540# VSS VSS nfet_03v3 ad=0.39p pd=2.02u as=0.39p ps=2.02u w=1.5u l=0.5u
X88 a_55266_65406# a_55266_65406# VDD VDD pfet_03v3 ad=2.6p pd=10.52u as=2.6p ps=10.52u w=10u l=2u
X89 perceptron_core_0.tanh_ota_0.V_in_p perceptron_core_0.tanh_ota_0.V_ref a_44195_67876# VSS nfet_03v3 ad=0.65p pd=3.02u as=0.65p ps=3.02u w=2.5u l=0.5u
X90 VSS a_53826_51058# a_53958_50954# VSS nfet_03v3 ad=0.65p pd=3.02u as=0.65p ps=3.02u w=2.5u l=2u
X91 perceptron_core_0.tanh_ota_0.V_ref a_54068_46311# VDD VSS nfet_03v3 ad=2.6p pd=10.52u as=2.6p ps=10.52u w=10u l=1u
X92 VSS a_53826_51058# a_53958_65406# VSS nfet_03v3 ad=0.65p pd=3.02u as=0.65p ps=3.02u w=2.5u l=2u
X93 VDD VDD a_64353_58580# VDD pfet_03v3 ad=6.5p pd=21.3u as=2.6p ps=10.52u w=10u l=1u
X94 a_44195_47782# V_w2_core perceptron_core_0.tanh_ota_0.V_in_n VSS nfet_03v3 ad=0.65p pd=3.02u as=0.65p ps=3.02u w=2.5u l=0.5u
X95 a_54068_69233# a_55266_65406# VDD VDD pfet_03v3 ad=2.6p pd=10.52u as=2.6p ps=10.52u w=10u l=2u
D15 VSS V_b_core diode_nd2ps_06v0 pj=40u area=99.99999p
X96 a_48931_54374# V_b_core perceptron_core_0.tanh_ota_0.V_in_n VSS nfet_03v3 ad=0.65p pd=3.02u as=0.65p ps=3.02u w=2.5u l=0.5u
X97 VSS VSS VSS VSS nfet_03v3 ad=0.39p pd=2.02u as=0 ps=0 w=1.5u l=0.5u
X98 a_43991_51280# perceptron_core_0.tanh_ota_0.V_ref perceptron_core_0.tanh_ota_0.V_in_n VSS nfet_03v3 ad=0.65p pd=3.02u as=0.65p ps=3.02u w=2.5u l=0.5u
X99 a_44174_53200# perceptron_core_0.tanh_ota_0.V_ref VSS VSS nfet_03v3 ad=1.04p pd=4.52u as=1.04p ps=4.52u w=4u l=1u
X100 a_48931_54374# perceptron_core_0.tanh_ota_0.V_ref perceptron_core_0.tanh_ota_0.V_in_p VSS nfet_03v3 ad=0.65p pd=3.02u as=0.65p ps=3.02u w=2.5u l=0.5u
X101 a_55266_65406# VDD VDD VDD pfet_03v3 ad=2.6p pd=10.52u as=6.5p ps=21.3u w=10u l=2u
X102 VDD a_48342_63968# V_out_perceptron_core VDD pfet_03v3 ad=1.3p pd=5.52u as=1.3p ps=5.52u w=5u l=0.5u
X103 a_62775_58580# VDD VDD VDD pfet_03v3 ad=1.3p pd=5.52u as=3.25p ps=11.3u w=5u l=1u
X104 a_55266_50954# a_55134_51058# a_53958_50954# VSS nfet_03v3 ad=1.3p pd=5.52u as=1.3p ps=5.52u w=5u l=2u
X105 a_48931_54374# V_b_core perceptron_core_0.tanh_ota_0.V_in_n VSS nfet_03v3 ad=0.65p pd=3.02u as=0.65p ps=3.02u w=2.5u l=0.5u
X106 perceptron_core_0.tanh_ota_0.V_in_n V_w2_core a_44195_47782# VSS nfet_03v3 ad=0.65p pd=3.02u as=0.65p ps=3.02u w=2.5u l=0.5u
X107 a_55134_65510# a_60043_58514# VSS ppolyf_u_1k r_width=3u r_length=20u
X108 a_44195_67876# perceptron_core_0.tanh_ota_0.V_ref perceptron_core_0.tanh_ota_0.V_in_p VSS nfet_03v3 ad=0.65p pd=3.02u as=0.65p ps=3.02u w=2.5u l=0.5u
X109 VDD a_54068_69233# perceptron_core_0.voltage_reference_0.v_1_25 VSS nfet_03v3 ad=2.6p pd=10.52u as=2.6p ps=10.52u w=10u l=1u
X110 a_60430_60950# a_67218_61332# VSS ppolyf_u_1k r_width=3u r_length=23u
X111 VSS VSS a_43991_66200# VSS nfet_03v3 ad=3.05p pd=11.22u as=1.3p ps=5.52u w=5u l=0.5u
X112 a_44195_67876# V_w1_core perceptron_core_0.tanh_ota_0.V_in_n VSS nfet_03v3 ad=0.65p pd=3.02u as=0.65p ps=3.02u w=2.5u l=0.5u
X113 VSS perceptron_core_0.tanh_ota_0.V_ref a_44174_53200# VSS nfet_03v3 ad=1.04p pd=4.52u as=1.04p ps=4.52u w=4u l=1u
X114 a_53906_61332# a_60034_60480# VSS ppolyf_u_1k r_width=3u r_length=30u
X115 a_54068_46311# perceptron_core_0.tanh_ota_0.V_ref a_53958_50954# VSS nfet_03v3 ad=1.3p pd=5.52u as=1.3p ps=5.52u w=5u l=2u
X116 VDD a_54068_69233# perceptron_core_0.voltage_reference_0.v_1_25 VSS nfet_03v3 ad=2.6p pd=10.52u as=2.6p ps=10.52u w=10u l=1u
X117 a_43991_66200# V_w1_core perceptron_core_0.tanh_ota_0.V_in_p VSS nfet_03v3 ad=0.65p pd=3.02u as=0.65p ps=3.02u w=2.5u l=0.5u
X118 a_52131_62540# a_52131_62540# VSS VSS nfet_03v3 ad=0.39p pd=2.02u as=0.39p ps=2.02u w=1.5u l=0.5u
D16 VSS V_out_perceptron_core diode_nd2ps_06v0 pj=40u area=99.99999p
D17 V_out_perceptron_core VDD diode_pd2nw_06v0 pj=40u area=99.99999p
D18 VSS V_out_perceptron_core diode_nd2ps_06v0 pj=40u area=99.99999p
X119 VSS VSS a_53826_51058# VSS nfet_03v3 ad=3.05p pd=11.22u as=1.3p ps=5.52u w=5u l=1u
X120 a_48342_63968# a_48342_63968# VDD VDD pfet_03v3 ad=1.3p pd=5.52u as=1.3p ps=5.52u w=5u l=0.5u
X121 a_43991_66200# perceptron_core_0.tanh_ota_0.V_ref perceptron_core_0.tanh_ota_0.V_in_n VSS nfet_03v3 ad=0.65p pd=3.02u as=0.65p ps=3.02u w=2.5u l=0.5u
X122 a_52131_62540# a_52131_62540# VSS VSS nfet_03v3 ad=0.39p pd=2.02u as=0.39p ps=2.02u w=1.5u l=0.5u
X123 a_55266_50954# VSS VSS VSS nfet_03v3 ad=1.3p pd=5.52u as=3.05p ps=11.22u w=5u l=2u
X124 perceptron_core_0.tanh_ota_0.V_ref a_54068_46311# VDD VSS nfet_03v3 ad=2.6p pd=10.52u as=2.6p ps=10.52u w=10u l=1u
X125 a_62775_58580# perceptron_core_0.voltage_reference_0.v_1_15 perceptron_core_0.voltage_reference_0.v_1_15 VDD pfet_03v3 ad=2.6p pd=10.52u as=2.6p ps=10.52u w=10u l=1u
X126 a_44195_47782# perceptron_core_0.voltage_reference_0.v_1_25 a_44174_53200# VSS nfet_03v3 ad=1.3p pd=5.52u as=1.3p ps=5.52u w=5u l=0.5u
X127 a_49772_52654# perceptron_core_0.tanh_ota_0.V_ref VSS VSS nfet_03v3 ad=1.04p pd=4.52u as=1.04p ps=4.52u w=4u l=1u
X128 perceptron_core_0.gilbert_multiplier_current_2.V_x_n perceptron_core_0.voltage_reference_0.v_1_25 VSS ppolyf_u_1k r_width=3u r_length=8.1u
X129 a_53958_50954# a_53826_51058# VSS VSS nfet_03v3 ad=0.65p pd=3.02u as=0.65p ps=3.02u w=2.5u l=2u
X130 a_44195_47782# VSS VSS VSS nfet_03v3 ad=1.3p pd=5.52u as=3.05p ps=11.22u w=5u l=0.5u
X131 VDD VDD a_55266_50954# VDD pfet_03v3 ad=6.5p pd=21.3u as=2.6p ps=10.52u w=10u l=2u
D19 VSS I_x2_core diode_nd2ps_06v0 pj=40u area=99.99999p
X132 a_44174_64480# perceptron_core_0.tanh_ota_0.V_ref VSS VSS nfet_03v3 ad=1.04p pd=4.52u as=1.04p ps=4.52u w=4u l=1u
D20 VSS V_w1_core diode_nd2ps_06v0 pj=40u area=99.99999p
X133 a_53958_50954# a_53826_51058# VSS VSS nfet_03v3 ad=0.65p pd=3.02u as=0.65p ps=3.02u w=2.5u l=2u
X134 a_62775_58580# a_60034_57400# VDD VDD pfet_03v3 ad=1.3p pd=5.52u as=1.3p ps=5.52u w=5u l=1u
X135 VSS a_60034_53992# VSS ppolyf_u_1k r_width=3u r_length=30u
X136 VDD a_55266_50954# a_54068_46311# VDD pfet_03v3 ad=2.6p pd=10.52u as=2.6p ps=10.52u w=10u l=2u
D21 VSS I_x2_core diode_nd2ps_06v0 pj=40u area=99.99999p
X137 a_49772_52654# a_49921_49178# VSS ppolyf_u_1k r_width=3u r_length=11.55u
X138 perceptron_core_0.voltage_reference_0.v_1_15 a_64353_58580# VSS VSS nfet_03v3 ad=1.3p pd=5.52u as=1.3p ps=5.52u w=5u l=1u
X139 perceptron_core_0.gilbert_multiplier_current_1.V_x_n perceptron_core_0.voltage_reference_0.v_1_25 VSS ppolyf_u_1k r_width=3u r_length=8.1u
X140 VSS perceptron_core_0.tanh_ota_0.V_ref a_44174_64480# VSS nfet_03v3 ad=1.04p pd=4.52u as=1.04p ps=4.52u w=4u l=1u
X141 V_out_perceptron V_out_perceptron_core VDD ppolyf_u r_width=40u r_length=10u
X142 a_53958_50954# VSS VSS VSS nfet_03v3 ad=0.65p pd=3.02u as=1.525p ps=6.22u w=2.5u l=2u
X143 VDD a_60034_57400# a_60034_57400# VDD pfet_03v3 ad=1.3p pd=5.52u as=1.3p ps=5.52u w=5u l=1u
X144 VDD a_55266_50954# a_55266_50954# VDD pfet_03v3 ad=2.6p pd=10.52u as=2.6p ps=10.52u w=10u l=2u
X145 a_48342_63968# perceptron_core_0.tanh_ota_0.V_in_p a_50871_64476# VSS nfet_03v3 ad=1.3p pd=5.52u as=1.3p ps=5.52u w=5u l=0.5u
X146 a_47887_67604# a_52415_68456# VSS ppolyf_u_1k r_width=3u r_length=22u
X147 VDD a_55266_65406# a_55266_65406# VDD pfet_03v3 ad=2.6p pd=10.52u as=2.6p ps=10.52u w=10u l=2u
D22 VSS I_x1_core diode_nd2ps_06v0 pj=40u area=99.99999p
X148 a_60490_53140# a_67218_53992# VSS ppolyf_u_1k r_width=3u r_length=33u
X149 a_43293_63442# a_43293_61004# VSS ppolyf_u_1k r_width=3u r_length=11.55u
D23 V_b_core VDD diode_pd2nw_06v0 pj=40u area=99.99999p
X150 a_52131_62540# a_52131_62540# VSS VSS nfet_03v3 ad=0.39p pd=2.02u as=0.39p ps=2.02u w=1.5u l=0.5u
X151 VSS VSS a_44195_67876# VSS nfet_03v3 ad=3.05p pd=11.22u as=1.3p ps=5.52u w=5u l=0.5u
X152 VSS VSS perceptron_core_0.tanh_ota_0.V_in_p VSS nfet_03v3 ad=1.525p pd=6.22u as=0.65p ps=3.02u w=2.5u l=0.5u
X153 a_44174_64480# perceptron_core_0.voltage_reference_0.v_1_25 a_44195_67876# VSS nfet_03v3 ad=1.3p pd=5.52u as=1.3p ps=5.52u w=5u l=0.5u
X154 a_44195_67876# V_w1_core perceptron_core_0.tanh_ota_0.V_in_n VSS nfet_03v3 ad=0.65p pd=3.02u as=0.65p ps=3.02u w=2.5u l=0.5u
X155 a_43293_57348# a_43293_54910# VSS ppolyf_u_1k r_width=3u r_length=11.55u
X156 VDD VDD a_48342_63968# VDD pfet_03v3 ad=3.25p pd=11.3u as=1.3p ps=5.52u w=5u l=0.5u
X157 VDD a_54068_69233# perceptron_core_0.voltage_reference_0.v_1_25 VSS nfet_03v3 ad=2.6p pd=10.52u as=2.6p ps=10.52u w=10u l=1u
X158 VSS VSS perceptron_core_0.tanh_ota_0.V_in_p VSS nfet_03v3 ad=1.525p pd=6.22u as=0.65p ps=3.02u w=2.5u l=0.5u
X159 a_47887_69308# a_52415_70160# VSS ppolyf_u_1k r_width=3u r_length=22u
X160 VSS a_52131_62540# a_52131_62540# VSS nfet_03v3 ad=0.39p pd=2.02u as=0.39p ps=2.02u w=1.5u l=0.5u
X161 a_43991_51280# V_w2_core perceptron_core_0.tanh_ota_0.V_in_p VSS nfet_03v3 ad=0.65p pd=3.02u as=0.65p ps=3.02u w=2.5u l=0.5u
X162 a_43991_66200# perceptron_core_0.tanh_ota_0.V_ref perceptron_core_0.tanh_ota_0.V_in_n VSS nfet_03v3 ad=0.65p pd=3.02u as=0.65p ps=3.02u w=2.5u l=0.5u
X163 perceptron_core_0.tanh_ota_0.V_in_n V_w1_core a_44195_67876# VSS nfet_03v3 ad=0.65p pd=3.02u as=0.65p ps=3.02u w=2.5u l=0.5u
X164 a_43991_51280# perceptron_core_0.tanh_ota_0.V_ref perceptron_core_0.tanh_ota_0.V_in_n VSS nfet_03v3 ad=0.65p pd=3.02u as=0.65p ps=3.02u w=2.5u l=0.5u
X165 VDD a_48342_63968# a_48342_63968# VDD pfet_03v3 ad=1.3p pd=5.52u as=1.3p ps=5.52u w=5u l=0.5u
X166 a_43991_66200# perceptron_core_0.tanh_ota_0.V_ref perceptron_core_0.tanh_ota_0.V_in_n VSS nfet_03v3 ad=0.65p pd=3.02u as=0.65p ps=3.02u w=2.5u l=0.5u
D24 V_w1_core VDD diode_pd2nw_06v0 pj=40u area=99.99999p
X167 perceptron_core_0.tanh_ota_0.V_in_p perceptron_core_0.tanh_ota_0.V_ref a_44195_67876# VSS nfet_03v3 ad=0.65p pd=3.02u as=0.65p ps=3.02u w=2.5u l=0.5u
X168 a_43991_66200# VSS VSS VSS nfet_03v3 ad=1.3p pd=5.52u as=3.05p ps=11.22u w=5u l=0.5u
X169 a_43991_66200# V_w1_core perceptron_core_0.tanh_ota_0.V_in_p VSS nfet_03v3 ad=0.65p pd=3.02u as=0.65p ps=3.02u w=2.5u l=0.5u
X170 I_x2 I_x2_core VDD ppolyf_u r_width=40u r_length=10u
X171 a_48233_51616# perceptron_core_0.tanh_ota_0.V_ref VSS VSS nfet_03v3 ad=1.04p pd=4.52u as=1.04p ps=4.52u w=4u l=1u
X172 perceptron_core_0.tanh_ota_0.V_in_p VSS VSS VSS nfet_03v3 ad=0.65p pd=3.02u as=1.525p ps=6.22u w=2.5u l=0.5u
D25 V_w2_core VDD diode_pd2nw_06v0 pj=40u area=99.99999p
X173 a_52131_62540# a_52131_62540# VSS VSS nfet_03v3 ad=0.39p pd=2.02u as=0.39p ps=2.02u w=1.5u l=0.5u
D26 V_shift_core VDD diode_pd2nw_06v0 pj=40u area=99.99999p
X174 VSS VSS a_48342_63968# VSS nfet_03v3 ad=3.05p pd=11.22u as=1.3p ps=5.52u w=5u l=0.5u
X175 a_55266_50954# a_55266_50954# VDD VDD pfet_03v3 ad=2.6p pd=10.52u as=2.6p ps=10.52u w=10u l=2u
X176 perceptron_core_0.tanh_ota_0.V_in_p VSS VSS VSS nfet_03v3 ad=0.65p pd=3.02u as=1.525p ps=6.22u w=2.5u l=0.5u
X177 perceptron_core_0.voltage_reference_0.v_1_25 a_54068_69233# VDD VSS nfet_03v3 ad=2.6p pd=10.52u as=2.6p ps=10.52u w=10u l=1u
X178 perceptron_core_0.tanh_ota_0.V_in_p perceptron_core_0.tanh_ota_0.V_ref a_44195_47782# VSS nfet_03v3 ad=0.65p pd=3.02u as=0.65p ps=3.02u w=2.5u l=0.5u
X179 a_52131_62540# a_52131_62540# VSS VSS nfet_03v3 ad=0.39p pd=2.02u as=0.39p ps=2.02u w=1.5u l=0.5u
X180 perceptron_core_0.tanh_ota_0.V_in_n V_w2_core a_44195_47782# VSS nfet_03v3 ad=0.65p pd=3.02u as=0.65p ps=3.02u w=2.5u l=0.5u
X181 a_54068_46311# a_55266_50954# VDD VDD pfet_03v3 ad=2.6p pd=10.52u as=2.6p ps=10.52u w=10u l=2u
X182 a_64353_58580# VSS VSS VSS nfet_03v3 ad=1.3p pd=5.52u as=3.05p ps=11.22u w=5u l=1u
D27 V_w2_core VDD diode_pd2nw_06v0 pj=40u area=99.99999p
X183 a_62490_62184# a_67218_63036# VSS ppolyf_u_1k r_width=3u r_length=23u
X184 a_43293_54910# perceptron_core_0.gilbert_multiplier_current_1.V_x_n a_43991_51280# VSS nfet_03v3 ad=1.3p pd=5.52u as=1.3p ps=5.52u w=5u l=0.5u
D28 VSS V_w2_core diode_nd2ps_06v0 pj=40u area=99.99999p
X185 perceptron_core_0.tanh_ota_0.V_in_n VSS VSS VSS nfet_03v3 ad=0.65p pd=3.02u as=1.525p ps=6.22u w=2.5u l=0.5u
X186 a_53906_63036# a_60034_62184# VSS ppolyf_u_1k r_width=3u r_length=30u
X187 VDD VSS VSS VSS nfet_03v3 ad=2.6p pd=10.52u as=6.1p ps=21.22u w=10u l=1u
X188 a_55266_50954# VDD VDD VDD pfet_03v3 ad=2.6p pd=10.52u as=6.5p ps=21.3u w=10u l=2u
D29 I_x1_core VDD diode_pd2nw_06v0 pj=40u area=99.99999p
D30 VSS V_w1_core diode_nd2ps_06v0 pj=40u area=99.99999p
X189 V_out_perceptron_core a_48342_63968# VDD VDD pfet_03v3 ad=1.3p pd=5.52u as=1.3p ps=5.52u w=5u l=0.5u
X190 perceptron_core_0.tanh_ota_0.V_ref a_54068_46311# VDD VSS nfet_03v3 ad=2.6p pd=10.52u as=2.6p ps=10.52u w=10u l=1u
D31 VSS V_w2_core diode_nd2ps_06v0 pj=40u area=99.99999p
X191 perceptron_core_0.voltage_reference_0.v_1_15 perceptron_core_0.voltage_reference_0.v_1_15 a_62775_58580# VDD pfet_03v3 ad=2.6p pd=10.52u as=2.6p ps=10.52u w=10u l=1u
X192 VSS VSS perceptron_core_0.tanh_ota_0.V_in_p VSS nfet_03v3 ad=1.525p pd=6.22u as=0.65p ps=3.02u w=2.5u l=0.5u
D32 I_x2_core VDD diode_pd2nw_06v0 pj=40u area=99.99999p
X193 VSS VSS perceptron_core_0.tanh_ota_0.V_in_n VSS nfet_03v3 ad=1.525p pd=6.22u as=0.65p ps=3.02u w=2.5u l=0.5u
X194 a_55134_51058# a_60043_58514# VSS ppolyf_u_1k r_width=3u r_length=20u
D33 V_shift_core VDD diode_pd2nw_06v0 pj=40u area=99.99999p
X195 V_shift_core perceptron_core_0.tanh_ota_0.V_in_p VSS ppolyf_u_1k r_width=3u r_length=7.3u
X196 a_43991_51280# perceptron_core_0.tanh_ota_0.V_ref perceptron_core_0.tanh_ota_0.V_in_n VSS nfet_03v3 ad=0.65p pd=3.02u as=0.65p ps=3.02u w=2.5u l=0.5u
X197 a_49135_56824# V_b_core perceptron_core_0.tanh_ota_0.V_in_p VSS nfet_03v3 ad=0.65p pd=3.02u as=0.65p ps=3.02u w=2.5u l=0.5u
X198 VSS VSS perceptron_core_0.tanh_ota_0.V_in_n VSS nfet_03v3 ad=1.525p pd=6.22u as=0.65p ps=3.02u w=2.5u l=0.5u
X199 perceptron_core_0.tanh_ota_0.V_in_n V_w1_core a_44195_67876# VSS nfet_03v3 ad=0.65p pd=3.02u as=0.65p ps=3.02u w=2.5u l=0.5u
X200 a_53906_54844# a_60034_55696# VSS ppolyf_u_1k r_width=3u r_length=30u
X201 a_44195_47782# V_w2_core perceptron_core_0.tanh_ota_0.V_in_n VSS nfet_03v3 ad=0.65p pd=3.02u as=0.65p ps=3.02u w=2.5u l=0.5u
X202 a_43991_66200# V_w1_core perceptron_core_0.tanh_ota_0.V_in_p VSS nfet_03v3 ad=0.65p pd=3.02u as=0.65p ps=3.02u w=2.5u l=0.5u
X203 a_43293_54910# perceptron_core_0.tanh_ota_0.V_ref VSS VSS nfet_03v3 ad=1.04p pd=4.52u as=1.04p ps=4.52u w=4u l=1u
X204 a_64353_58580# a_64353_58580# VSS VSS nfet_03v3 ad=1.3p pd=5.52u as=1.3p ps=5.52u w=5u l=1u
X205 VSS a_52131_62540# a_52131_62540# VSS nfet_03v3 ad=0.39p pd=2.02u as=0.39p ps=2.02u w=1.5u l=0.5u
X206 a_44137_63442# a_44981_61004# VSS ppolyf_u_1k r_width=3u r_length=11.55u
X207 a_44195_47782# perceptron_core_0.tanh_ota_0.V_ref perceptron_core_0.tanh_ota_0.V_in_p VSS nfet_03v3 ad=0.65p pd=3.02u as=0.65p ps=3.02u w=2.5u l=0.5u
X208 I_x2_core perceptron_core_0.voltage_reference_0.v_1_25 perceptron_core_0.gilbert_multiplier_current_1.V_x_n VSS nfet_03v3 ad=1.525p pd=6.22u as=0.65p ps=3.02u w=2.5u l=0.5u
D34 I_x1_core VDD diode_pd2nw_06v0 pj=40u area=99.99999p
X209 a_43991_66200# perceptron_core_0.gilbert_multiplier_current_2.V_x_n a_43293_63442# VSS nfet_03v3 ad=1.3p pd=5.52u as=1.3p ps=5.52u w=5u l=0.5u
X210 V_w1 V_w1_core VDD ppolyf_u r_width=40u r_length=10u
X211 perceptron_core_0.tanh_ota_0.V_in_n V_w1_core a_44195_67876# VSS nfet_03v3 ad=0.65p pd=3.02u as=0.65p ps=3.02u w=2.5u l=0.5u
X212 a_43991_51280# perceptron_core_0.tanh_ota_0.V_ref perceptron_core_0.tanh_ota_0.V_in_n VSS nfet_03v3 ad=0.65p pd=3.02u as=0.65p ps=3.02u w=2.5u l=0.5u
X213 a_48931_54374# VSS VSS VSS nfet_03v3 ad=1.3p pd=5.52u as=3.05p ps=11.22u w=5u l=0.5u
X214 VDD VDD a_60034_57400# VDD pfet_03v3 ad=3.25p pd=11.3u as=1.3p ps=5.52u w=5u l=1u
X215 V_out_perceptron_core a_49529_59702# VSS ppolyf_u_1k r_width=3u r_length=15u
X216 a_43991_51280# V_w2_core perceptron_core_0.tanh_ota_0.V_in_p VSS nfet_03v3 ad=0.65p pd=3.02u as=0.65p ps=3.02u w=2.5u l=0.5u
D35 VSS V_w1_core diode_nd2ps_06v0 pj=40u area=99.99999p
X217 perceptron_core_0.tanh_ota_0.V_in_p VSS VSS VSS nfet_03v3 ad=0.65p pd=3.02u as=1.525p ps=6.22u w=2.5u l=0.5u
X218 a_44981_57348# a_44137_54910# VSS ppolyf_u_1k r_width=3u r_length=11.55u
X219 perceptron_core_0.tanh_ota_0.V_in_n perceptron_core_0.tanh_ota_0.V_ref a_43991_66200# VSS nfet_03v3 ad=0.65p pd=3.02u as=0.65p ps=3.02u w=2.5u l=0.5u
X220 a_60490_54844# a_67218_55696# VSS ppolyf_u_1k r_width=3u r_length=33u
D36 I_x1_core VDD diode_pd2nw_06v0 pj=40u area=99.99999p
X221 perceptron_core_0.tanh_ota_0.V_in_p perceptron_core_0.tanh_ota_0.V_ref a_44195_47782# VSS nfet_03v3 ad=0.65p pd=3.02u as=0.65p ps=3.02u w=2.5u l=0.5u
X222 perceptron_core_0.tanh_ota_0.V_in_p VSS VSS VSS nfet_03v3 ad=0.65p pd=3.02u as=1.525p ps=6.22u w=2.5u l=0.5u
X223 perceptron_core_0.tanh_ota_0.V_in_n VSS VSS VSS nfet_03v3 ad=0.65p pd=3.02u as=1.525p ps=6.22u w=2.5u l=0.5u
X224 a_52131_62540# a_52131_62540# VSS VSS nfet_03v3 ad=0.39p pd=2.02u as=0.39p ps=2.02u w=1.5u l=0.5u
X225 a_44195_67876# V_w1_core perceptron_core_0.tanh_ota_0.V_in_n VSS nfet_03v3 ad=0.65p pd=3.02u as=0.65p ps=3.02u w=2.5u l=0.5u
X226 a_48342_63968# a_48342_63968# VDD VDD pfet_03v3 ad=1.3p pd=5.52u as=1.3p ps=5.52u w=5u l=0.5u
X227 VSS VSS a_49135_56824# VSS nfet_03v3 ad=3.05p pd=11.22u as=1.3p ps=5.52u w=5u l=0.5u
X228 a_48233_51616# VSS VSS VSS nfet_03v3 ad=1.04p pd=4.52u as=2.44p ps=9.22u w=4u l=1u
X229 perceptron_core_0.tanh_ota_0.V_in_n perceptron_core_0.tanh_ota_0.V_ref a_49135_56824# VSS nfet_03v3 ad=0.65p pd=3.02u as=0.65p ps=3.02u w=2.5u l=0.5u
X230 I_x1_core perceptron_core_0.voltage_reference_0.v_1_25 perceptron_core_0.gilbert_multiplier_current_2.V_x_n VSS nfet_03v3 ad=1.525p pd=6.22u as=0.65p ps=3.02u w=2.5u l=0.5u
X231 a_49772_52654# perceptron_core_0.voltage_reference_0.v_1_15 a_49135_56824# VSS nfet_03v3 ad=1.3p pd=5.52u as=1.3p ps=5.52u w=5u l=0.5u
X232 a_50871_64476# perceptron_core_0.tanh_ota_0.V_in_n V_out_perceptron_core VSS nfet_03v3 ad=1.3p pd=5.52u as=1.3p ps=5.52u w=5u l=0.5u
X233 perceptron_core_0.tanh_ota_0.V_in_p V_b_core a_49135_56824# VSS nfet_03v3 ad=0.65p pd=3.02u as=0.65p ps=3.02u w=2.5u l=0.5u
X234 a_43293_63442# perceptron_core_0.tanh_ota_0.V_ref VSS VSS nfet_03v3 ad=1.04p pd=4.52u as=1.04p ps=4.52u w=4u l=1u
X235 VSS a_52131_62540# a_52131_62540# VSS nfet_03v3 ad=0.39p pd=2.02u as=0.39p ps=2.02u w=1.5u l=0.5u
X236 VSS VSS perceptron_core_0.tanh_ota_0.V_in_p VSS nfet_03v3 ad=1.525p pd=6.22u as=0.65p ps=3.02u w=2.5u l=0.5u
X237 VSS a_52131_62540# a_52131_62540# VSS nfet_03v3 ad=0.39p pd=2.02u as=0.39p ps=2.02u w=1.5u l=0.5u
X238 a_47887_67604# a_52131_62540# VSS ppolyf_u_1k r_width=3u r_length=22u
X239 a_44195_47782# perceptron_core_0.tanh_ota_0.V_ref perceptron_core_0.tanh_ota_0.V_in_p VSS nfet_03v3 ad=0.65p pd=3.02u as=0.65p ps=3.02u w=2.5u l=0.5u
X240 a_49135_56824# perceptron_core_0.tanh_ota_0.V_ref perceptron_core_0.tanh_ota_0.V_in_n VSS nfet_03v3 ad=0.65p pd=3.02u as=0.65p ps=3.02u w=2.5u l=0.5u
X241 a_53826_51058# VSS VSS VSS nfet_03v3 ad=1.3p pd=5.52u as=3.05p ps=11.22u w=5u l=1u
X242 VDD a_54068_46311# perceptron_core_0.tanh_ota_0.V_ref VSS nfet_03v3 ad=2.6p pd=10.52u as=2.6p ps=10.52u w=10u l=1u
X243 I_x1 I_x1_core VDD ppolyf_u r_width=40u r_length=10u
X244 a_64353_58580# VDD VDD VDD pfet_03v3 ad=2.6p pd=10.52u as=6.5p ps=21.3u w=10u l=1u
D37 V_w2_core VDD diode_pd2nw_06v0 pj=40u area=99.99999p
X245 a_52131_62540# a_52131_62540# VSS VSS nfet_03v3 ad=0.39p pd=2.02u as=0.39p ps=2.02u w=1.5u l=0.5u
X246 VSS VSS perceptron_core_0.tanh_ota_0.V_in_n VSS nfet_03v3 ad=1.525p pd=6.22u as=0.65p ps=3.02u w=2.5u l=0.5u
X247 perceptron_core_0.voltage_reference_0.v_1_25 a_54068_69233# VDD VSS nfet_03v3 ad=2.6p pd=10.52u as=2.6p ps=10.52u w=10u l=1u
X248 perceptron_core_0.tanh_ota_0.V_ref a_54068_46311# VDD VSS nfet_03v3 ad=2.6p pd=10.52u as=2.6p ps=10.52u w=10u l=1u
D38 VSS V_b_core diode_nd2ps_06v0 pj=40u area=99.99999p
X249 a_44195_47782# perceptron_core_0.tanh_ota_0.V_ref perceptron_core_0.tanh_ota_0.V_in_p VSS nfet_03v3 ad=0.65p pd=3.02u as=0.65p ps=3.02u w=2.5u l=0.5u
X250 a_48342_63968# VDD VDD VDD pfet_03v3 ad=1.3p pd=5.52u as=3.25p ps=11.3u w=5u l=0.5u
X251 perceptron_core_0.tanh_ota_0.V_in_p VSS VSS VSS nfet_03v3 ad=0.65p pd=3.02u as=1.525p ps=6.22u w=2.5u l=0.5u
D39 V_shift_core VDD diode_pd2nw_06v0 pj=40u area=99.99999p
D40 I_x1_core VDD diode_pd2nw_06v0 pj=40u area=99.99999p
X252 VDD a_60034_57400# a_62775_58580# VDD pfet_03v3 ad=1.3p pd=5.52u as=1.3p ps=5.52u w=5u l=1u
X253 VSS VSS perceptron_core_0.tanh_ota_0.V_in_n VSS nfet_03v3 ad=1.525p pd=6.22u as=0.65p ps=3.02u w=2.5u l=0.5u
D41 VSS V_b_core diode_nd2ps_06v0 pj=40u area=99.99999p
X254 a_43991_51280# V_w2_core perceptron_core_0.tanh_ota_0.V_in_p VSS nfet_03v3 ad=0.65p pd=3.02u as=0.65p ps=3.02u w=2.5u l=0.5u
X255 a_60490_53140# VDD VSS ppolyf_u_1k r_width=3u r_length=33u
D42 VSS V_w1_core diode_nd2ps_06v0 pj=40u area=99.99999p
X256 a_48931_54374# perceptron_core_0.voltage_reference_0.v_1_25 a_48233_51616# VSS nfet_03v3 ad=1.3p pd=5.52u as=1.3p ps=5.52u w=5u l=0.5u
X257 a_44137_63442# a_43293_61004# VSS ppolyf_u_1k r_width=3u r_length=11.55u
X258 perceptron_core_0.tanh_ota_0.V_in_n perceptron_core_0.tanh_ota_0.V_ref a_43991_51280# VSS nfet_03v3 ad=0.65p pd=3.02u as=0.65p ps=3.02u w=2.5u l=0.5u
X259 perceptron_core_0.tanh_ota_0.V_in_p V_b_core a_49135_56824# VSS nfet_03v3 ad=0.65p pd=3.02u as=0.65p ps=3.02u w=2.5u l=0.5u
X260 perceptron_core_0.tanh_ota_0.V_in_n VSS VSS VSS nfet_03v3 ad=0.65p pd=3.02u as=1.525p ps=6.22u w=2.5u l=0.5u
X261 VSS VSS perceptron_core_0.tanh_ota_0.V_in_p VSS nfet_03v3 ad=1.525p pd=6.22u as=0.65p ps=3.02u w=2.5u l=0.5u
X262 perceptron_core_0.tanh_ota_0.V_in_n perceptron_core_0.tanh_ota_0.V_ref a_49135_56824# VSS nfet_03v3 ad=0.65p pd=3.02u as=0.65p ps=3.02u w=2.5u l=0.5u
X263 perceptron_core_0.tanh_ota_0.V_in_p V_w1_core a_43991_66200# VSS nfet_03v3 ad=0.65p pd=3.02u as=0.65p ps=3.02u w=2.5u l=0.5u
X264 VSS a_52131_62540# a_50871_64476# VSS nfet_03v3 ad=0.39p pd=2.02u as=0.39p ps=2.02u w=1.5u l=0.5u
X265 a_43293_57348# a_44137_54910# VSS ppolyf_u_1k r_width=3u r_length=11.55u
X266 a_49077_51616# a_48233_49178# VSS ppolyf_u_1k r_width=3u r_length=11.55u
X267 a_48931_54374# V_b_core perceptron_core_0.tanh_ota_0.V_in_n VSS nfet_03v3 ad=0.65p pd=3.02u as=0.65p ps=3.02u w=2.5u l=0.5u
X268 a_64353_58580# a_60430_60950# a_62775_58580# VDD pfet_03v3 ad=2.6p pd=10.52u as=2.6p ps=10.52u w=10u l=1u
X269 perceptron_core_0.tanh_ota_0.V_in_n VSS VSS VSS nfet_03v3 ad=0.65p pd=3.02u as=1.525p ps=6.22u w=2.5u l=0.5u
X270 a_48233_51616# a_48233_49178# VSS ppolyf_u_1k r_width=3u r_length=11.55u
X271 perceptron_core_0.tanh_ota_0.V_in_n VSS VSS VSS nfet_03v3 ad=0.65p pd=3.02u as=1.525p ps=6.22u w=2.5u l=0.5u
D43 VSS V_shift_core diode_nd2ps_06v0 pj=40u area=99.99999p
X272 VDD perceptron_core_0.tanh_ota_0.V_in_n VSS ppolyf_u_1k r_width=3u r_length=7.3u
X273 a_44195_67876# perceptron_core_0.voltage_reference_0.v_1_25 a_44174_64480# VSS nfet_03v3 ad=1.3p pd=5.52u as=1.3p ps=5.52u w=5u l=0.5u
D44 V_w1_core VDD diode_pd2nw_06v0 pj=40u area=99.99999p
X274 a_52131_62540# a_52131_62540# VSS VSS nfet_03v3 ad=0.39p pd=2.02u as=0.39p ps=2.02u w=1.5u l=0.5u
X275 perceptron_core_0.tanh_ota_0.V_in_p perceptron_core_0.tanh_ota_0.V_ref a_44195_67876# VSS nfet_03v3 ad=0.65p pd=3.02u as=0.65p ps=3.02u w=2.5u l=0.5u
X276 a_44195_67876# VSS VSS VSS nfet_03v3 ad=1.3p pd=5.52u as=3.05p ps=11.22u w=5u l=0.5u
X277 V_out_perceptron_core a_48342_63968# VDD VDD pfet_03v3 ad=1.3p pd=5.52u as=1.3p ps=5.52u w=5u l=0.5u
X278 perceptron_core_0.tanh_ota_0.V_in_n V_w1_core a_44195_67876# VSS nfet_03v3 ad=0.65p pd=3.02u as=0.65p ps=3.02u w=2.5u l=0.5u
X279 a_50381_62830# perceptron_core_0.tanh_ota_0.V_ref VSS ppolyf_u_1k r_width=3u r_length=15u
X280 VSS VSS a_44174_53200# VSS nfet_03v3 ad=2.44p pd=9.22u as=1.04p ps=4.52u w=4u l=1u
X281 perceptron_core_0.tanh_ota_0.V_in_p V_w1_core a_43991_66200# VSS nfet_03v3 ad=0.65p pd=3.02u as=0.65p ps=3.02u w=2.5u l=0.5u
X282 V_b V_b_core VDD ppolyf_u r_width=40u r_length=10u
X283 VSS VSS perceptron_core_0.tanh_ota_0.V_in_n VSS nfet_03v3 ad=1.525p pd=6.22u as=0.65p ps=3.02u w=2.5u l=0.5u
X284 perceptron_core_0.tanh_ota_0.V_in_n perceptron_core_0.tanh_ota_0.V_ref a_43991_66200# VSS nfet_03v3 ad=0.65p pd=3.02u as=0.65p ps=3.02u w=2.5u l=0.5u
X285 a_53826_51058# a_60034_60480# VSS ppolyf_u_1k r_width=3u r_length=30u
D45 I_x2_core VDD diode_pd2nw_06v0 pj=40u area=99.99999p
X286 a_48931_54374# perceptron_core_0.tanh_ota_0.V_ref perceptron_core_0.tanh_ota_0.V_in_p VSS nfet_03v3 ad=0.65p pd=3.02u as=0.65p ps=3.02u w=2.5u l=0.5u
X287 perceptron_core_0.tanh_ota_0.V_in_p perceptron_core_0.tanh_ota_0.V_ref a_48931_54374# VSS nfet_03v3 ad=0.65p pd=3.02u as=0.65p ps=3.02u w=2.5u l=0.5u
X288 perceptron_core_0.tanh_ota_0.V_in_n V_b_core a_48931_54374# VSS nfet_03v3 ad=0.65p pd=3.02u as=0.65p ps=3.02u w=2.5u l=0.5u
X289 VSS VSS a_43991_51280# VSS nfet_03v3 ad=3.05p pd=11.22u as=1.3p ps=5.52u w=5u l=0.5u
X290 a_53906_56548# a_60034_57400# VSS ppolyf_u_1k r_width=3u r_length=30u
X291 VSS perceptron_core_0.voltage_reference_0.v_1_25 VSS ppolyf_u_1k r_width=3u r_length=20u
X292 a_53906_54844# a_60034_53992# VSS ppolyf_u_1k r_width=3u r_length=30u
X293 VDD VDD a_62775_58580# VDD pfet_03v3 ad=3.25p pd=11.3u as=1.3p ps=5.52u w=5u l=1u
X294 VSS VSS a_55266_65406# VSS nfet_03v3 ad=3.05p pd=11.22u as=1.3p ps=5.52u w=5u l=2u
D46 I_x2_core VDD diode_pd2nw_06v0 pj=40u area=99.99999p
X295 perceptron_core_0.voltage_reference_0.v_1_25 a_54068_69233# VDD VSS nfet_03v3 ad=2.6p pd=10.52u as=2.6p ps=10.52u w=10u l=1u
X296 a_52131_62540# a_52131_62540# VSS VSS nfet_03v3 ad=0.39p pd=2.02u as=0.39p ps=2.02u w=1.5u l=0.5u
X297 VSS perceptron_core_0.tanh_ota_0.V_ref a_49772_52654# VSS nfet_03v3 ad=1.04p pd=4.52u as=1.04p ps=4.52u w=4u l=1u
X298 a_50871_64476# perceptron_core_0.tanh_ota_0.V_in_p a_48342_63968# VSS nfet_03v3 ad=1.3p pd=5.52u as=1.3p ps=5.52u w=5u l=0.5u
X299 perceptron_core_0.voltage_reference_0.v_1_25 a_54068_69233# VDD VSS nfet_03v3 ad=2.6p pd=10.52u as=2.6p ps=10.52u w=10u l=1u
X300 a_47887_69308# a_52415_68456# VSS ppolyf_u_1k r_width=3u r_length=22u
D47 VSS I_x2_core diode_nd2ps_06v0 pj=40u area=99.99999p
X301 perceptron_core_0.tanh_ota_0.V_in_p perceptron_core_0.tanh_ota_0.V_ref a_44195_47782# VSS nfet_03v3 ad=0.65p pd=3.02u as=0.65p ps=3.02u w=2.5u l=0.5u
X302 a_53958_65406# perceptron_core_0.voltage_reference_0.v_1_25 a_54068_69233# VSS nfet_03v3 ad=1.3p pd=5.52u as=1.3p ps=5.52u w=5u l=2u
X303 VSS VSS a_44174_64480# VSS nfet_03v3 ad=2.44p pd=9.22u as=1.04p ps=4.52u w=4u l=1u
X304 VSS a_52131_62540# a_52131_62540# VSS nfet_03v3 ad=0.39p pd=2.02u as=0.39p ps=2.02u w=1.5u l=0.5u
D48 V_out_perceptron_core VDD diode_pd2nw_06v0 pj=40u area=99.99999p
D49 VSS V_shift_core diode_nd2ps_06v0 pj=40u area=99.99999p
X305 a_44174_53200# VSS VSS VSS nfet_03v3 ad=1.04p pd=4.52u as=2.44p ps=9.22u w=4u l=1u
X306 a_53826_51058# a_53826_51058# VSS VSS nfet_03v3 ad=1.3p pd=5.52u as=1.3p ps=5.52u w=5u l=1u
X307 a_60490_54844# a_67218_53992# VSS ppolyf_u_1k r_width=3u r_length=33u
X308 VDD a_48342_63968# V_out_perceptron_core VDD pfet_03v3 ad=1.3p pd=5.52u as=1.3p ps=5.52u w=5u l=0.5u
X309 perceptron_core_0.tanh_ota_0.V_in_p V_w2_core a_43991_51280# VSS nfet_03v3 ad=0.65p pd=3.02u as=0.65p ps=3.02u w=2.5u l=0.5u
X310 VDD a_54068_46311# perceptron_core_0.tanh_ota_0.V_ref VSS nfet_03v3 ad=2.6p pd=10.52u as=2.6p ps=10.52u w=10u l=1u
X311 perceptron_core_0.tanh_ota_0.V_in_n V_b_core a_48931_54374# VSS nfet_03v3 ad=0.65p pd=3.02u as=0.65p ps=3.02u w=2.5u l=0.5u
D50 VSS I_x2_core diode_nd2ps_06v0 pj=40u area=99.99999p
D51 VSS V_shift_core diode_nd2ps_06v0 pj=40u area=99.99999p
X312 perceptron_core_0.tanh_ota_0.V_in_p perceptron_core_0.tanh_ota_0.V_ref a_48931_54374# VSS nfet_03v3 ad=0.65p pd=3.02u as=0.65p ps=3.02u w=2.5u l=0.5u
X313 V_out_perceptron_core perceptron_core_0.tanh_ota_0.V_in_n a_50871_64476# VSS nfet_03v3 ad=1.3p pd=5.52u as=1.3p ps=5.52u w=5u l=0.5u
X314 VSS VSS a_53958_65406# VSS nfet_03v3 ad=1.525p pd=6.22u as=0.65p ps=3.02u w=2.5u l=2u
X315 a_44174_64480# a_44981_61004# VSS ppolyf_u_1k r_width=3u r_length=11.55u
X316 VSS VSS VDD VSS nfet_03v3 ad=6.1p pd=21.22u as=2.6p ps=10.52u w=10u l=1u
X317 VDD a_52415_70160# VSS ppolyf_u_1k r_width=3u r_length=22u
D52 V_b_core VDD diode_pd2nw_06v0 pj=40u area=99.99999p
X318 perceptron_core_0.tanh_ota_0.V_in_p perceptron_core_0.tanh_ota_0.V_ref a_44195_67876# VSS nfet_03v3 ad=0.65p pd=3.02u as=0.65p ps=3.02u w=2.5u l=0.5u
X319 VDD a_60034_57400# a_62775_58580# VDD pfet_03v3 ad=1.3p pd=5.52u as=1.3p ps=5.52u w=5u l=1u
X320 VSS a_53826_51058# a_53958_65406# VSS nfet_03v3 ad=0.65p pd=3.02u as=0.65p ps=3.02u w=2.5u l=2u
X321 VSS a_64353_58580# a_64353_58580# VSS nfet_03v3 ad=1.3p pd=5.52u as=1.3p ps=5.52u w=5u l=1u
X322 perceptron_core_0.tanh_ota_0.V_in_p V_w2_core a_43991_51280# VSS nfet_03v3 ad=0.65p pd=3.02u as=0.65p ps=3.02u w=2.5u l=0.5u
X323 perceptron_core_0.tanh_ota_0.V_in_n perceptron_core_0.tanh_ota_0.V_ref a_49135_56824# VSS nfet_03v3 ad=0.65p pd=3.02u as=0.65p ps=3.02u w=2.5u l=0.5u
X324 a_44981_57348# a_44174_53200# VSS ppolyf_u_1k r_width=3u r_length=11.55u
X325 perceptron_core_0.tanh_ota_0.V_in_p V_w1_core a_43991_66200# VSS nfet_03v3 ad=0.65p pd=3.02u as=0.65p ps=3.02u w=2.5u l=0.5u
X326 a_44195_67876# V_w1_core perceptron_core_0.tanh_ota_0.V_in_n VSS nfet_03v3 ad=0.65p pd=3.02u as=0.65p ps=3.02u w=2.5u l=0.5u
X327 perceptron_core_0.tanh_ota_0.V_in_p V_b_core a_49135_56824# VSS nfet_03v3 ad=0.65p pd=3.02u as=0.65p ps=3.02u w=2.5u l=0.5u
X328 perceptron_core_0.tanh_ota_0.V_in_n perceptron_core_0.tanh_ota_0.V_ref a_43991_51280# VSS nfet_03v3 ad=0.65p pd=3.02u as=0.65p ps=3.02u w=2.5u l=0.5u
X329 a_49077_51616# a_49921_49178# VSS ppolyf_u_1k r_width=3u r_length=11.55u
X330 perceptron_core_0.tanh_ota_0.V_in_n perceptron_core_0.tanh_ota_0.V_ref a_43991_66200# VSS nfet_03v3 ad=0.65p pd=3.02u as=0.65p ps=3.02u w=2.5u l=0.5u
X331 a_60034_57400# VDD VDD VDD pfet_03v3 ad=1.3p pd=5.52u as=3.25p ps=11.3u w=5u l=1u
X332 a_44195_67876# perceptron_core_0.tanh_ota_0.V_ref perceptron_core_0.tanh_ota_0.V_in_p VSS nfet_03v3 ad=0.65p pd=3.02u as=0.65p ps=3.02u w=2.5u l=0.5u
X333 VSS VSS a_44195_47782# VSS nfet_03v3 ad=3.05p pd=11.22u as=1.3p ps=5.52u w=5u l=0.5u
X334 a_44174_64480# VSS VSS VSS nfet_03v3 ad=1.04p pd=4.52u as=2.44p ps=9.22u w=4u l=1u
X335 perceptron_core_0.tanh_ota_0.V_in_p V_w1_core a_43991_66200# VSS nfet_03v3 ad=0.65p pd=3.02u as=0.65p ps=3.02u w=2.5u l=0.5u
X336 a_44174_53200# perceptron_core_0.voltage_reference_0.v_1_25 a_44195_47782# VSS nfet_03v3 ad=1.3p pd=5.52u as=1.3p ps=5.52u w=5u l=0.5u
X337 perceptron_core_0.gilbert_multiplier_current_1.V_x_n perceptron_core_0.voltage_reference_0.v_1_25 I_x2_core VSS nfet_03v3 ad=0.65p pd=3.02u as=1.525p ps=6.22u w=2.5u l=0.5u
X338 a_43293_63442# perceptron_core_0.gilbert_multiplier_current_2.V_x_n a_43991_66200# VSS nfet_03v3 ad=1.3p pd=5.52u as=1.3p ps=5.52u w=5u l=0.5u
X339 a_44195_67876# perceptron_core_0.tanh_ota_0.V_ref perceptron_core_0.tanh_ota_0.V_in_p VSS nfet_03v3 ad=0.65p pd=3.02u as=0.65p ps=3.02u w=2.5u l=0.5u
X340 a_62490_63888# VSS VSS ppolyf_u_1k r_width=3u r_length=23u
X341 VDD a_54068_46311# perceptron_core_0.tanh_ota_0.V_ref VSS nfet_03v3 ad=2.6p pd=10.52u as=2.6p ps=10.52u w=10u l=1u
X342 VSS a_52131_62540# a_52131_62540# VSS nfet_03v3 ad=0.39p pd=2.02u as=0.39p ps=2.02u w=1.5u l=0.5u
D53 V_out_perceptron_core VDD diode_pd2nw_06v0 pj=40u area=99.99999p
D54 V_out_perceptron_core VDD diode_pd2nw_06v0 pj=40u area=99.99999p
X343 a_43991_66200# V_w1_core perceptron_core_0.tanh_ota_0.V_in_p VSS nfet_03v3 ad=0.65p pd=3.02u as=0.65p ps=3.02u w=2.5u l=0.5u
D55 VSS V_w2_core diode_nd2ps_06v0 pj=40u area=99.99999p
X344 a_44195_47782# perceptron_core_0.tanh_ota_0.V_ref perceptron_core_0.tanh_ota_0.V_in_p VSS nfet_03v3 ad=0.65p pd=3.02u as=0.65p ps=3.02u w=2.5u l=0.5u
X345 VSS VSS a_48233_51616# VSS nfet_03v3 ad=2.44p pd=9.22u as=1.04p ps=4.52u w=4u l=1u
X346 a_44195_47782# V_w2_core perceptron_core_0.tanh_ota_0.V_in_n VSS nfet_03v3 ad=0.65p pd=3.02u as=0.65p ps=3.02u w=2.5u l=0.5u
X347 a_43991_51280# VSS VSS VSS nfet_03v3 ad=1.3p pd=5.52u as=3.05p ps=11.22u w=5u l=0.5u
C0 perceptron_core_0.voltage_reference_0.v_1_25 a_54068_69233# 3.7839f
C1 V_out_perceptron_core perceptron_core_0.tanh_ota_0.V_ref 0
C2 perceptron_core_0.tanh_ota_0.V_ref perceptron_core_0.gilbert_multiplier_current_2.V_x_n 0.02515f
C3 VDD a_60034_57400# 6.14308f
C4 a_55134_51058# a_53906_54844# 0.00953f
C5 V_w1 VDD 19.389f
C6 V_w2_core perceptron_core_0.voltage_reference_0.v_1_25 0.00333f
C7 perceptron_core_0.voltage_reference_0.v_1_15 a_60430_60950# 0.17122f
C8 I_x2 VDD 19.3964f
C9 V_b_core perceptron_core_0.voltage_reference_0.v_1_25 0.16024f
C10 VDD a_54068_69233# 4.32068f
C11 a_44195_47782# a_44174_53200# 0.77598f
C12 a_44174_64480# perceptron_core_0.tanh_ota_0.V_in_n 0.10508f
C13 V_w2_core perceptron_core_0.gilbert_multiplier_current_1.V_x_n 0.00333f
C14 a_62775_58580# a_60430_60950# 0.77357f
C15 perceptron_core_0.voltage_reference_0.v_1_15 a_53826_51058# 0.08069f
C16 V_w2_core VDD 38.9038f
C17 V_w1_core perceptron_core_0.tanh_ota_0.V_in_p 1.09485f
C18 a_49529_59702# V_out_perceptron_core 0
C19 V_b_core perceptron_core_0.gilbert_multiplier_current_1.V_x_n 0.00705f
C20 V_b_core VDD 38.9012f
C21 I_x1_core perceptron_core_0.tanh_ota_0.V_in_p 0.12135f
C22 a_67218_55696# VDD 0.08026f
C23 a_48233_49178# a_49921_49178# 0.01656f
C24 a_44174_53200# perceptron_core_0.tanh_ota_0.V_in_n 0.03112f
C25 perceptron_core_0.gilbert_multiplier_current_2.V_x_n a_43293_61004# 0.05207f
C26 a_60043_58514# a_60034_55696# 0
C27 a_52131_62540# perceptron_core_0.tanh_ota_0.V_in_p 0.12224f
C28 a_47887_67604# perceptron_core_0.tanh_ota_0.V_in_p 0.00479f
C29 a_43293_57348# a_44981_57348# 0.01656f
C30 a_48931_54374# a_49135_56824# 0.13501f
C31 a_60430_60950# a_60034_60480# 0.02115f
C32 a_48342_63968# perceptron_core_0.tanh_ota_0.V_in_p 0.36364f
C33 perceptron_core_0.voltage_reference_0.v_1_15 a_53906_54844# 0.0037f
C34 a_52131_62540# a_52415_68456# 0.0161f
C35 a_44195_67876# perceptron_core_0.gilbert_multiplier_current_2.V_x_n 0
C36 perceptron_core_0.voltage_reference_0.v_1_25 perceptron_core_0.tanh_ota_0.V_ref 1.59128f
C37 a_60490_53140# a_60034_53992# 0.08585f
C38 V_b_core a_49135_56824# 0.65271f
C39 a_60490_53140# perceptron_core_0.voltage_reference_0.v_1_15 0.03725f
C40 I_x2_core perceptron_core_0.voltage_reference_0.v_1_25 0.20987f
C41 a_50381_62830# a_50871_64476# 0
C42 a_49772_52654# perceptron_core_0.voltage_reference_0.v_1_15 0.30482f
C43 a_60490_53140# a_60490_54844# 0.0161f
C44 perceptron_core_0.tanh_ota_0.V_ref perceptron_core_0.gilbert_multiplier_current_1.V_x_n 0.03504f
C45 perceptron_core_0.tanh_ota_0.V_ref VDD 6.5962f
C46 a_53958_65406# a_53906_63036# 0
C47 I_x2_core perceptron_core_0.gilbert_multiplier_current_1.V_x_n 0.52208f
C48 I_x2_core VDD 38.9038f
C49 a_54068_46311# perceptron_core_0.tanh_ota_0.V_ref 3.7839f
C50 perceptron_core_0.voltage_reference_0.v_1_15 perceptron_core_0.tanh_ota_0.V_in_p 0
C51 a_53958_65406# V_out_perceptron_core 0.00195f
C52 a_55134_65510# a_53826_51058# 0.22359f
C53 a_43991_66200# perceptron_core_0.tanh_ota_0.V_ref 0.7469f
C54 a_44137_54910# a_43293_54910# 0.02724f
C55 a_53826_51058# a_53906_54844# 0.02924f
C56 perceptron_core_0.voltage_reference_0.v_1_25 a_43293_61004# 0.00402f
C57 VDD a_64353_58580# 1.45789f
C58 V_out_perceptron_core perceptron_core_0.tanh_ota_0.V_in_n 0.51062f
C59 a_48233_51616# perceptron_core_0.voltage_reference_0.v_1_25 0.37895f
C60 a_44137_54910# perceptron_core_0.tanh_ota_0.V_in_p 0
C61 perceptron_core_0.voltage_reference_0.v_1_25 a_44195_67876# 0.35627f
C62 a_49135_56824# perceptron_core_0.tanh_ota_0.V_ref 0.98267f
C63 a_60430_60950# a_62490_62184# 0.0161f
C64 a_48931_54374# V_b_core 0.72896f
C65 perceptron_core_0.voltage_reference_0.v_1_25 a_47887_69308# 0.00294f
C66 a_44195_67876# VDD 0.00546f
C67 a_55134_65510# a_55266_65406# 0.54051f
C68 V_w1_core perceptron_core_0.gilbert_multiplier_current_2.V_x_n 0.00333f
C69 a_44981_61004# perceptron_core_0.tanh_ota_0.V_ref 0.00372f
C70 a_43991_51280# a_43293_54910# 0.77529f
C71 I_x1_core perceptron_core_0.gilbert_multiplier_current_2.V_x_n 0.52208f
C72 a_53958_50954# perceptron_core_0.tanh_ota_0.V_ref 1.04852f
C73 a_60043_58514# a_60034_60480# 0.00264f
C74 a_53906_63036# a_52131_62540# 0.00441f
C75 a_53958_65406# perceptron_core_0.voltage_reference_0.v_1_25 1.04852f
C76 VDD a_47887_69308# 0.2502f
C77 a_44195_47782# perceptron_core_0.voltage_reference_0.v_1_25 0.16254f
C78 a_43991_51280# perceptron_core_0.tanh_ota_0.V_in_p 2.58652f
C79 V_out_perceptron_core a_52131_62540# 0.03103f
C80 a_44174_53200# a_44137_54910# 0.02791f
C81 VDD V_shift 19.389f
C82 a_55134_65510# a_62490_62184# 0.00325f
C83 a_43991_66200# a_44195_67876# 0.13501f
C84 a_67218_61332# a_64353_58580# 0
C85 V_shift_core perceptron_core_0.tanh_ota_0.V_in_n 0.03881f
C86 a_44195_47782# perceptron_core_0.gilbert_multiplier_current_1.V_x_n 0
C87 a_53958_65406# VDD 0.00179f
C88 a_48342_63968# V_out_perceptron_core 2.12528f
C89 a_48233_51616# a_49135_56824# 0
C90 perceptron_core_0.voltage_reference_0.v_1_25 perceptron_core_0.tanh_ota_0.V_in_n 1.18253f
C91 a_53906_56548# a_55134_51058# 0.0088f
C92 a_44981_61004# a_43293_61004# 0.01656f
C93 a_48931_54374# perceptron_core_0.tanh_ota_0.V_ref 0.88892f
C94 a_49077_51616# perceptron_core_0.tanh_ota_0.V_ref 0.03259f
C95 a_49772_52654# perceptron_core_0.tanh_ota_0.V_in_p 0
C96 perceptron_core_0.tanh_ota_0.V_in_p a_43293_54910# 0.28218f
C97 a_43293_57348# perceptron_core_0.tanh_ota_0.V_in_p 0.00686f
C98 a_67218_63036# a_67218_61332# 0.0161f
C99 perceptron_core_0.tanh_ota_0.V_in_n VDD 1.16046f
C100 a_50381_62830# perceptron_core_0.tanh_ota_0.V_in_n 0
C101 V_w1_core V_shift_core 0.6393f
C102 V_w2_core perceptron_core_0.tanh_ota_0.V_ref 3.92601f
C103 V_b_core perceptron_core_0.tanh_ota_0.V_ref 4.01697f
C104 a_43991_51280# a_44174_53200# 0
C105 V_w1_core perceptron_core_0.voltage_reference_0.v_1_25 0.00333f
C106 V_b_core I_x2_core 1.35461f
C107 I_x1_core perceptron_core_0.voltage_reference_0.v_1_25 0.20987f
C108 a_48931_54374# a_49529_59702# 0.00419f
C109 a_52415_70160# a_52415_68456# 0.0161f
C110 a_43991_66200# perceptron_core_0.tanh_ota_0.V_in_n 2.16944f
C111 perceptron_core_0.tanh_ota_0.V_in_p a_43293_63442# 0.31773f
C112 V_w1_core VDD 39.5499f
C113 VDD a_60034_55696# 0.07587f
C114 I_x1_core VDD 38.9012f
C115 a_52131_62540# perceptron_core_0.voltage_reference_0.v_1_25 0.0254f
C116 a_55266_50954# VDD 6.6799f
C117 a_60034_60480# a_60034_62184# 0.0161f
C118 a_44174_64480# perceptron_core_0.tanh_ota_0.V_in_p 0.03585f
C119 perceptron_core_0.voltage_reference_0.v_1_25 a_47887_67604# 0.10628f
C120 V_b_core a_49529_59702# 0.01286f
C121 a_67218_55696# a_64353_58580# 0
C122 a_48342_63968# V_shift_core 0.00117f
C123 a_44174_53200# a_43293_54910# 0.23395f
C124 a_55266_50954# a_54068_46311# 1.10709f
C125 a_55134_51058# VDD 0.07822f
C126 a_48931_54374# a_48233_51616# 0.77621f
C127 a_49135_56824# perceptron_core_0.tanh_ota_0.V_in_n 2.16944f
C128 a_48233_51616# a_49077_51616# 0.02791f
C129 a_48342_63968# perceptron_core_0.voltage_reference_0.v_1_25 0
C130 a_55134_51058# a_54068_46311# 0.03312f
C131 perceptron_core_0.voltage_reference_0.v_1_25 a_44981_57348# 0.02497f
C132 a_44174_64480# a_43293_63442# 0.23395f
C133 V_w1_core a_43991_66200# 0.65271f
C134 a_47887_67604# VDD 0.23421f
C135 a_53906_63036# a_53826_51058# 0.02924f
C136 a_50381_62830# a_52131_62540# 0.0059f
C137 a_55134_65510# a_60034_62184# 0.08837f
C138 a_44137_63442# perceptron_core_0.tanh_ota_0.V_in_p 0
C139 V_out_perceptron_core a_53826_51058# 0.13171f
C140 a_48342_63968# VDD 7.56513f
C141 a_44981_61004# perceptron_core_0.tanh_ota_0.V_in_n 0
C142 a_48342_63968# a_50381_62830# 0.00182f
C143 V_w2 VDD 19.3969f
C144 a_55134_65510# a_53906_63036# 0.01007f
C145 a_44137_63442# a_43293_63442# 0.02724f
C146 perceptron_core_0.voltage_reference_0.v_1_15 perceptron_core_0.voltage_reference_0.v_1_25 0.00769f
C147 a_44137_63442# a_44174_64480# 0.02791f
C148 a_53906_56548# a_53826_51058# 0.03052f
C149 a_53958_65406# a_54068_69233# 0.2532f
C150 a_49529_59702# perceptron_core_0.tanh_ota_0.V_ref 0.02255f
C151 a_60034_53992# VDD 0.07538f
C152 perceptron_core_0.voltage_reference_0.v_1_15 VDD 1.2947f
C153 a_44195_47782# V_w2_core 0.71689f
C154 a_55266_50954# a_53958_50954# 0.41277f
C155 a_67218_53992# VDD 0.09804f
C156 a_60490_54844# VDD 0.01292f
C157 a_44137_54910# perceptron_core_0.voltage_reference_0.v_1_25 0
C158 a_48931_54374# perceptron_core_0.tanh_ota_0.V_in_n 2.39106f
C159 a_53958_50954# a_55134_51058# 0.55708f
C160 a_62775_58580# VDD 1.80269f
C161 a_48233_51616# perceptron_core_0.tanh_ota_0.V_ref 0.34683f
C162 V_w1_core I_x1 0.70088f
C163 V_w2_core perceptron_core_0.tanh_ota_0.V_in_n 1.33403f
C164 a_44137_54910# perceptron_core_0.gilbert_multiplier_current_1.V_x_n 0
C165 a_53906_56548# a_53906_54844# 0.00587f
C166 V_out_perceptron_core a_52415_70160# 0.00296f
C167 V_b_core perceptron_core_0.tanh_ota_0.V_in_n 1.55496f
C168 perceptron_core_0.tanh_ota_0.V_ref a_44195_67876# 0.83293f
C169 V_out_perceptron_core perceptron_core_0.tanh_ota_0.V_in_p 0.13196f
C170 a_53826_51058# perceptron_core_0.voltage_reference_0.v_1_25 0.07725f
C171 a_60430_60950# VDD 1.69864f
C172 a_60034_57400# a_60034_55696# 0.01841f
C173 perceptron_core_0.tanh_ota_0.V_in_p perceptron_core_0.gilbert_multiplier_current_2.V_x_n 0.25121f
C174 perceptron_core_0.voltage_reference_0.v_1_15 a_49135_56824# 0.16229f
C175 a_55134_51058# a_60034_57400# 0.03563f
C176 VDD V_b 19.389f
C177 a_60034_60480# VDD 0.0951f
C178 V_out_perceptron VDD 19.389f
C179 V_out_perceptron_core a_52415_68456# 0.00247f
C180 perceptron_core_0.gilbert_multiplier_current_2.V_x_n a_43293_63442# 0.3651f
C181 a_55134_65510# perceptron_core_0.voltage_reference_0.v_1_25 1.47413f
C182 I_x1_core V_b_core 0.87103f
C183 a_44174_64480# perceptron_core_0.gilbert_multiplier_current_2.V_x_n 0.04166f
C184 a_44195_47782# perceptron_core_0.tanh_ota_0.V_ref 0.92892f
C185 a_53958_50954# perceptron_core_0.voltage_reference_0.v_1_15 0.05166f
C186 a_55134_65510# VDD 0.09051f
C187 a_43991_51280# perceptron_core_0.gilbert_multiplier_current_1.V_x_n 0.16229f
C188 a_50871_64476# perceptron_core_0.tanh_ota_0.V_in_n 0.17229f
C189 perceptron_core_0.tanh_ota_0.V_ref perceptron_core_0.tanh_ota_0.V_in_n 6.49808f
C190 a_49772_52654# perceptron_core_0.voltage_reference_0.v_1_25 0
C191 a_55266_65406# perceptron_core_0.voltage_reference_0.v_1_25 0.2801f
C192 perceptron_core_0.voltage_reference_0.v_1_25 a_43293_54910# 0
C193 a_43293_57348# perceptron_core_0.voltage_reference_0.v_1_25 0.0064f
C194 a_44137_63442# perceptron_core_0.gilbert_multiplier_current_2.V_x_n 0
C195 V_shift_core perceptron_core_0.tanh_ota_0.V_in_p 0.04934f
C196 a_60490_53140# VDD 0.0373f
C197 perceptron_core_0.voltage_reference_0.v_1_25 perceptron_core_0.tanh_ota_0.V_in_p 0.44798f
C198 perceptron_core_0.voltage_reference_0.v_1_15 a_60034_57400# 0.01193f
C199 a_43293_54910# perceptron_core_0.gilbert_multiplier_current_1.V_x_n 0.3651f
C200 a_43293_57348# perceptron_core_0.gilbert_multiplier_current_1.V_x_n 0.05238f
C201 a_55266_65406# VDD 6.6799f
C202 a_48931_54374# perceptron_core_0.voltage_reference_0.v_1_15 0
C203 a_49529_59702# perceptron_core_0.tanh_ota_0.V_in_n 0.0011f
C204 a_52415_70160# VDD 0.0475f
C205 perceptron_core_0.voltage_reference_0.v_1_25 a_43293_63442# 0
C206 V_w1_core perceptron_core_0.tanh_ota_0.V_ref 3.92601f
C207 perceptron_core_0.tanh_ota_0.V_in_p perceptron_core_0.gilbert_multiplier_current_1.V_x_n 0.20574f
C208 perceptron_core_0.voltage_reference_0.v_1_25 a_52415_68456# 0.05065f
C209 a_62775_58580# a_60034_57400# 0.65869f
C210 perceptron_core_0.tanh_ota_0.V_in_p VDD 0.11052f
C211 a_53958_50954# a_53826_51058# 0.70424f
C212 a_55266_50954# perceptron_core_0.tanh_ota_0.V_ref 0.28006f
C213 a_53906_61332# a_52131_62540# 0
C214 a_50381_62830# perceptron_core_0.tanh_ota_0.V_in_p 0.0388f
C215 a_50871_64476# a_52131_62540# 0.17848f
C216 V_b_core perceptron_core_0.voltage_reference_0.v_1_15 0.00333f
C217 a_44174_64480# perceptron_core_0.voltage_reference_0.v_1_25 0.61396f
C218 a_55134_51058# perceptron_core_0.tanh_ota_0.V_ref 1.47413f
C219 perceptron_core_0.voltage_reference_0.v_1_15 a_67218_55696# 0.02041f
C220 a_52415_68456# VDD 0
C221 a_60430_60950# a_60034_57400# 0.06245f
C222 a_67218_53992# a_67218_55696# 0.0161f
C223 a_48233_51616# perceptron_core_0.tanh_ota_0.V_in_n 0.17076f
C224 a_48342_63968# a_50871_64476# 1.10067f
C225 a_60043_58514# VDD 0.39186f
C226 perceptron_core_0.tanh_ota_0.V_in_p a_43991_66200# 2.72648f
C227 a_53906_63036# V_out_perceptron_core 0.00168f
C228 a_44174_64480# VDD 0.00331f
C229 a_44174_53200# perceptron_core_0.voltage_reference_0.v_1_25 0.72971f
C230 a_49772_52654# a_49135_56824# 0.77508f
C231 perceptron_core_0.tanh_ota_0.V_in_n a_44195_67876# 2.37371f
C232 a_48342_63968# perceptron_core_0.tanh_ota_0.V_ref 0.06904f
C233 a_62490_63888# a_62490_62184# 0.0161f
C234 a_44137_63442# perceptron_core_0.voltage_reference_0.v_1_25 0
C235 perceptron_core_0.tanh_ota_0.V_ref a_44981_57348# 0.00372f
C236 a_43991_66200# a_43293_63442# 0.77452f
C237 I_x1_core a_43293_61004# 0.00197f
C238 a_49135_56824# perceptron_core_0.tanh_ota_0.V_in_p 2.58855f
C239 a_44174_53200# perceptron_core_0.gilbert_multiplier_current_1.V_x_n 0.04166f
C240 perceptron_core_0.tanh_ota_0.V_in_n a_47887_69308# 0.00281f
C241 a_44174_64480# a_43991_66200# 0
C242 a_49921_49178# perceptron_core_0.tanh_ota_0.V_ref 0.01755f
C243 V_w1_core a_44195_67876# 0.71915f
C244 a_44195_47782# perceptron_core_0.tanh_ota_0.V_in_n 2.37444f
C245 a_55134_65510# a_54068_69233# 0.03312f
C246 a_44981_61004# perceptron_core_0.tanh_ota_0.V_in_p 0.00777f
C247 perceptron_core_0.voltage_reference_0.v_1_15 perceptron_core_0.tanh_ota_0.V_ref 0.14918f
C248 a_43991_51280# V_w2_core 0.65431f
C249 a_47887_67604# a_44195_67876# 0
C250 perceptron_core_0.voltage_reference_0.v_1_15 a_64353_58580# 0.84737f
C251 a_49772_52654# a_48931_54374# 0
C252 a_44137_54910# perceptron_core_0.tanh_ota_0.V_ref 0.03093f
C253 a_49772_52654# a_49077_51616# 0.02724f
C254 VDD a_60034_62184# 0.09195f
C255 a_47887_67604# a_47887_69308# 0.0161f
C256 a_55266_65406# a_54068_69233# 1.10709f
C257 a_53826_51058# a_53906_61332# 0.03953f
C258 V_out_perceptron_core perceptron_core_0.voltage_reference_0.v_1_25 0.09239f
C259 a_50871_64476# a_53826_51058# 0
C260 perceptron_core_0.voltage_reference_0.v_1_25 perceptron_core_0.gilbert_multiplier_current_2.V_x_n 0.21462f
C261 a_52415_70160# a_54068_69233# 0.00339f
C262 a_62775_58580# a_64353_58580# 0.99499f
C263 a_48931_54374# perceptron_core_0.tanh_ota_0.V_in_p 2.00137f
C264 a_53958_65406# a_52131_62540# 0
C265 V_w1_core perceptron_core_0.tanh_ota_0.V_in_n 1.32892f
C266 a_53826_51058# perceptron_core_0.tanh_ota_0.V_ref 0.39048f
C267 a_48233_51616# perceptron_core_0.voltage_reference_0.v_1_15 0.03568f
C268 a_55134_65510# a_53906_61332# 0.0074f
C269 V_out_perceptron_core VDD 41.5047f
C270 perceptron_core_0.gilbert_multiplier_current_2.V_x_n perceptron_core_0.gilbert_multiplier_current_1.V_x_n 0
C271 a_60043_58514# a_60034_57400# 0.01424f
C272 V_w2_core perceptron_core_0.tanh_ota_0.V_in_p 1.12751f
C273 a_50381_62830# V_out_perceptron_core 0.06311f
C274 a_60430_60950# a_64353_58580# 0.62866f
C275 V_b_core perceptron_core_0.tanh_ota_0.V_in_p 2.43096f
C276 a_52415_68456# a_54068_69233# 0.00156f
C277 a_48233_49178# perceptron_core_0.tanh_ota_0.V_ref 0.01755f
C278 a_52131_62540# perceptron_core_0.tanh_ota_0.V_in_n 0.01441f
C279 a_47887_67604# perceptron_core_0.tanh_ota_0.V_in_n 0.01732f
C280 a_43991_51280# perceptron_core_0.tanh_ota_0.V_ref 0.75193f
C281 a_43991_66200# perceptron_core_0.gilbert_multiplier_current_2.V_x_n 0.16229f
C282 a_48342_63968# perceptron_core_0.tanh_ota_0.V_in_n 0.47423f
C283 a_55134_51058# a_60034_55696# 0.15325f
C284 a_55266_50954# a_55134_51058# 0.54051f
C285 V_shift_core perceptron_core_0.voltage_reference_0.v_1_25 0.09992f
C286 a_49772_52654# perceptron_core_0.tanh_ota_0.V_ref 0.46508f
C287 perceptron_core_0.tanh_ota_0.V_ref a_43293_54910# 0.26733f
C288 a_50871_64476# perceptron_core_0.tanh_ota_0.V_in_p 0.14065f
C289 a_43293_57348# I_x2_core 0.00139f
C290 V_shift_core VDD 39.743f
C291 perceptron_core_0.tanh_ota_0.V_in_p perceptron_core_0.tanh_ota_0.V_ref 5.95733f
C292 perceptron_core_0.voltage_reference_0.v_1_25 perceptron_core_0.gilbert_multiplier_current_1.V_x_n 0.21459f
C293 I_x2_core perceptron_core_0.tanh_ota_0.V_in_p 0.0817f
C294 perceptron_core_0.voltage_reference_0.v_1_25 VDD 6.79869f
C295 perceptron_core_0.tanh_ota_0.V_ref a_43293_63442# 0.26229f
C296 a_48342_63968# a_52131_62540# 0.03652f
C297 a_60034_53992# a_60034_55696# 0.0161f
C298 a_53958_65406# a_53826_51058# 0.70429f
C299 a_44174_64480# perceptron_core_0.tanh_ota_0.V_ref 0.45119f
C300 a_49529_59702# perceptron_core_0.tanh_ota_0.V_in_p 0.08037f
C301 a_54068_46311# VDD 3.92843f
C302 a_55266_50954# perceptron_core_0.voltage_reference_0.v_1_15 0.05968f
C303 a_49772_52654# a_48233_51616# 0.23395f
C304 a_60490_54844# a_60034_55696# 0.08585f
C305 perceptron_core_0.voltage_reference_0.v_1_15 a_55134_51058# 0.08983f
C306 perceptron_core_0.tanh_ota_0.V_in_p a_43293_61004# 0.01311f
C307 a_44174_53200# perceptron_core_0.tanh_ota_0.V_ref 0.46973f
C308 a_55134_65510# a_53958_65406# 0.55712f
C309 a_55134_51058# a_60490_54844# 0.0161f
C310 V_out_perceptron_core a_54068_69233# 0.00194f
C311 a_44195_47782# a_43991_51280# 0.13501f
C312 a_44137_63442# perceptron_core_0.tanh_ota_0.V_ref 0.03093f
C313 perceptron_core_0.tanh_ota_0.V_in_p a_44195_67876# 2.13719f
C314 V_b_core perceptron_core_0.gilbert_multiplier_current_2.V_x_n 0
C315 a_44981_61004# perceptron_core_0.voltage_reference_0.v_1_25 0.02497f
C316 a_43991_51280# perceptron_core_0.tanh_ota_0.V_in_n 2.16944f
C317 a_44195_67876# a_43293_63442# 0
C318 a_53958_65406# a_55266_65406# 0.41277f
C319 a_44195_47782# a_43293_54910# 0
C320 a_44174_64480# a_44195_67876# 0.7754f
C321 a_55134_51058# a_53826_51058# 0.215f
C322 perceptron_core_0.voltage_reference_0.v_1_15 a_60034_53992# 0.01849f
C323 a_53958_50954# VDD 0.00179f
C324 a_44195_47782# perceptron_core_0.tanh_ota_0.V_in_p 1.99792f
C325 a_53906_63036# a_53906_61332# 0.00587f
C326 a_53958_50954# a_54068_46311# 0.2532f
C327 a_53826_51058# a_52131_62540# 0.22118f
C328 a_60034_53992# a_60490_54844# 0.08585f
C329 perceptron_core_0.voltage_reference_0.v_1_15 a_67218_53992# 0.02284f
C330 V_out_perceptron_core a_53906_61332# 0.00214f
C331 perceptron_core_0.voltage_reference_0.v_1_15 a_60490_54844# 0.0037f
C332 a_50871_64476# V_out_perceptron_core 0.75246f
C333 perceptron_core_0.voltage_reference_0.v_1_15 a_62775_58580# 1.5168f
C334 a_55134_65510# a_55134_51058# 0.02642f
C335 a_48931_54374# perceptron_core_0.voltage_reference_0.v_1_25 0.16254f
C336 I_x1 VDD 20.4084f
C337 perceptron_core_0.tanh_ota_0.V_in_p perceptron_core_0.tanh_ota_0.V_in_n 8.79808f
C338 V_w2 VSS 6.36988f
C339 I_x2 VSS 6.3711f
C340 V_b VSS 6.38499f
C341 I_x1 VSS 35.447f
C342 V_out_perceptron VSS 6.38499f
C343 V_shift VSS 6.38499f
C344 V_w1 VSS 6.38499f
C345 VDD VSS 1.80867p
C346 a_54068_46311# VSS 6.90433f
C347 a_55266_50954# VSS 1.43767f
C348 a_53958_50954# VSS 1.63765f
C349 a_49921_49178# VSS 1.3734f
C350 a_49077_51616# VSS 1.59945f
C351 a_48233_49178# VSS 1.37744f
C352 V_w2_core VSS 85.848f
C353 a_44195_47782# VSS 3.2564f
C354 a_43991_51280# VSS 2.66531f
C355 a_60490_53140# VSS 1.26323f
C356 a_67218_53992# VSS 1.52344f
C357 a_60034_53992# VSS 1.15657f
C358 a_49772_52654# VSS 2.86328f
C359 a_48233_51616# VSS 3.44657f
C360 a_44174_53200# VSS 3.30825f
C361 a_60490_54844# VSS 1.22088f
C362 a_53906_54844# VSS 1.66578f
C363 a_67218_55696# VSS 1.64278f
C364 a_60034_55696# VSS 1.25524f
C365 a_53906_56548# VSS 1.67099f
C366 perceptron_core_0.voltage_reference_0.v_1_15 VSS 8.23164f
C367 a_64353_58580# VSS 4.54862f
C368 a_62775_58580# VSS 0.12817f
C369 a_49135_56824# VSS 2.47344f
C370 a_44981_57348# VSS 1.36843f
C371 a_44137_54910# VSS 1.59921f
C372 a_43293_54910# VSS 2.68403f
C373 a_43293_57348# VSS 1.42226f
C374 a_60034_57400# VSS 1.70911f
C375 a_55134_51058# VSS 9.00053f
C376 a_60043_58514# VSS 1.06213f
C377 a_48931_54374# VSS 3.16083f
C378 perceptron_core_0.gilbert_multiplier_current_1.V_x_n VSS 5.12409f
C379 a_60430_60950# VSS 3.18764f
C380 a_67218_61332# VSS 1.72144f
C381 a_60034_60480# VSS 1.30485f
C382 a_53906_61332# VSS 1.80316f
C383 a_62490_62184# VSS 1.38373f
C384 a_60034_62184# VSS 1.29609f
C385 a_67218_63036# VSS 1.61377f
C386 a_53906_63036# VSS 1.65403f
C387 a_62490_63888# VSS 1.37777f
C388 a_55134_65510# VSS 9.0181f
C389 a_55266_65406# VSS 1.43767f
C390 a_53826_51058# VSS 17.2623f
C391 a_53958_65406# VSS 1.68973f
C392 a_50381_62830# VSS 1.58768f
C393 a_49529_59702# VSS 1.38267f
C394 a_50871_64476# VSS 0.59657f
C395 a_48342_63968# VSS 1.44377f
C396 a_44981_61004# VSS 1.36822f
C397 a_44137_63442# VSS 1.59946f
C398 a_43293_61004# VSS 1.43413f
C399 I_x2_core VSS 76.41261f
C400 a_44174_64480# VSS 3.32452f
C401 a_43293_63442# VSS 2.6771f
C402 perceptron_core_0.gilbert_multiplier_current_2.V_x_n VSS 5.12717f
C403 a_52131_62540# VSS 12.766f
C404 perceptron_core_0.voltage_reference_0.v_1_25 VSS 21.9821f
C405 a_54068_69233# VSS 6.85617f
C406 a_47887_67604# VSS 1.21892f
C407 a_52415_68456# VSS 1.59488f
C408 a_43991_66200# VSS 2.66531f
C409 a_47887_69308# VSS 1.20881f
C410 perceptron_core_0.tanh_ota_0.V_in_p VSS 18.4333f
C411 a_44195_67876# VSS 3.1909f
C412 perceptron_core_0.tanh_ota_0.V_in_n VSS 12.9603f
C413 perceptron_core_0.tanh_ota_0.V_ref VSS 46.3341f
C414 a_52415_70160# VSS 1.60478f
C415 V_b_core VSS 86.1644f
C416 I_x1_core VSS 77.8353f
C417 V_out_perceptron_core VSS 82.79739f
C418 V_shift_core VSS 82.0301f
C419 V_w1_core VSS 90.03629f
.ends perceptron_pex_c
