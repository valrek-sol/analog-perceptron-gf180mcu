* perceptron_core_pex_rc — Magic RC extraction of perceptron_core (layout/perceptron/perceptron_core.gds)
* generated by pex/pex.tcl, see pex/out/env.txt for provenance
* ports (schematic order): VDD V_shift V_w1 I_x1 V_out_perceptron V_b I_x2 V_w2 VSS
* NGSPICE file created from perceptron_core.ext - technology: gf180mcuD

.subckt perceptron_core_pex_rc VDD V_shift V_w1 I_x1 V_out_perceptron V_b I_x2 V_w2 VSS
X0 a_8355_9194# tanh_ota_0.V_ref tanh_ota_0.V_in_p VSS.t58 nfet_03v3 ad=0.65p pd=3.02u as=0.65p ps=3.02u w=2.5u l=0.5u
X1 a_3415_6100# tanh_ota_0.V_ref tanh_ota_0.V_in_n VSS.t81 nfet_03v3 ad=0.65p pd=3.02u as=0.65p ps=3.02u w=2.5u l=0.5u
X2 a_2717_18262# a_2717_15824# VSS.t32 ppolyf_u_1k r_width=3u r_length=11.55u
X3 a_8355_9194# V_b.t13 tanh_ota_0.V_in_n VSS.t62 nfet_03v3 ad=0.65p pd=3.02u as=0.65p ps=3.02u w=2.5u l=0.5u
X4 VDD.t44 a_14690_20226# a_14690_20226# VDD.t43 pfet_03v3 ad=2.6p pd=10.52u as=2.6p ps=10.52u w=10u l=2u
X5 a_8355_9194# V_b.t2 tanh_ota_0.V_in_n VSS.t57 nfet_03v3 ad=0.65p pd=3.02u as=0.65p ps=3.02u w=2.5u l=0.5u
X6 a_3415_6100# V_w2.t7 tanh_ota_0.V_in_p VSS.t7 nfet_03v3 ad=0.65p pd=3.02u as=0.65p ps=3.02u w=2.5u l=0.5u
X7 a_3619_22696# V_w1.t0 tanh_ota_0.V_in_n VSS.t47 nfet_03v3 ad=0.65p pd=3.02u as=0.65p ps=3.02u w=2.5u l=0.5u
X8 a_3598_19300# voltage_reference_0.v_1_25 a_3619_22696# VSS.t88 nfet_03v3 ad=1.3p pd=5.52u as=1.3p ps=5.52u w=5u l=0.5u
X9 a_7766_18788# VDD.t67 VDD.t69 VDD.t68 pfet_03v3 ad=1.3p pd=5.52u as=3.25p ps=11.3u w=5u l=0.5u
X10 a_19854_15770# a_26642_16152# VSS.t9 ppolyf_u_1k r_width=3u r_length=23u
X11 a_8355_9194# tanh_ota_0.V_ref tanh_ota_0.V_in_p VSS.t60 nfet_03v3 ad=0.65p pd=3.02u as=0.65p ps=3.02u w=2.5u l=0.5u
X12 a_3619_22696# tanh_ota_0.V_ref tanh_ota_0.V_in_p VSS.t44 nfet_03v3 ad=0.65p pd=3.02u as=0.65p ps=3.02u w=2.5u l=0.5u
X13 a_3619_22696# tanh_ota_0.V_ref tanh_ota_0.V_in_p VSS.t47 nfet_03v3 ad=0.65p pd=3.02u as=0.65p ps=3.02u w=2.5u l=0.5u
X14 a_8559_11644# VSS.t206 VSS.t207 VSS.t103 nfet_03v3 ad=1.3p pd=5.52u as=3.05p ps=11.22u w=5u l=0.5u
X15 a_3619_22696# V_w1.t15 tanh_ota_0.V_in_n VSS.t44 nfet_03v3 ad=0.65p pd=3.02u as=0.65p ps=3.02u w=2.5u l=0.5u
X16 a_3415_21020# tanh_ota_0.V_ref tanh_ota_0.V_in_n VSS.t45 nfet_03v3 ad=0.65p pd=3.02u as=0.65p ps=3.02u w=2.5u l=0.5u
X17 a_11555_17360# a_11555_17360# VSS.t281 VSS.t280 nfet_03v3 ad=0.39p pd=2.02u as=0.39p ps=2.02u w=1.5u l=0.5u
X18 a_11555_17360# a_11555_17360# VSS.t295 VSS.t294 nfet_03v3 ad=0.39p pd=2.02u as=0.39p ps=2.02u w=1.5u l=0.5u
X19 a_13330_17856# VDD.t36 VSS.t102 ppolyf_u_1k r_width=3u r_length=30u
X20 a_3619_2602# V_w2.t12 tanh_ota_0.V_in_n VSS.t85 nfet_03v3 ad=0.65p pd=3.02u as=0.65p ps=3.02u w=2.5u l=0.5u
X21 a_3415_21020# V_w1.t9 tanh_ota_0.V_in_p VSS.t45 nfet_03v3 ad=0.65p pd=3.02u as=0.65p ps=3.02u w=2.5u l=0.5u
X22 VDD.t29 a_13492_24053# voltage_reference_0.v_1_25 VSS.t95 nfet_03v3 ad=2.6p pd=10.52u as=2.6p ps=10.52u w=10u l=1u
X23 a_7766_18788# VSS.t128 VSS.t130 VSS.t129 nfet_03v3 ad=1.3p pd=5.52u as=3.05p ps=11.22u w=5u l=0.5u
X24 a_13250_5878# VSS.t122 VSS.t124 VSS.t123 nfet_03v3 ad=1.3p pd=5.52u as=3.05p ps=11.22u w=5u l=1u
X25 VSS.t138 VSS.t137 tanh_ota_0.V_in_n VSS.t46 nfet_03v3 ad=1.525p pd=6.22u as=0.65p ps=3.02u w=2.5u l=0.5u
X26 a_3598_19300# a_4405_15824# VSS.t101 ppolyf_u_1k r_width=3u r_length=11.55u
X27 a_23777_13400# VDD.t85 VDD.t86 VDD.t35 pfet_03v3 ad=2.6p pd=10.52u as=6.5p ps=21.3u w=10u l=1u
X28 a_3561_18262# a_4405_15824# VSS.t5 ppolyf_u_1k r_width=3u r_length=11.55u
X29 VSS.t178 VSS.t177 tanh_ota_0.V_in_n VSS.t58 nfet_03v3 ad=1.525p pd=6.22u as=0.65p ps=3.02u w=2.5u l=0.5u
X30 a_3415_6100# tanh_ota_0.V_ref tanh_ota_0.V_in_n VSS.t85 nfet_03v3 ad=0.65p pd=3.02u as=0.65p ps=3.02u w=2.5u l=0.5u
X31 a_7657_6436# VSS.t224 VSS.t226 VSS.t225 nfet_03v3 ad=1.04p pd=4.52u as=2.44p ps=9.22u w=4u l=1u
X32 VSS.t279 a_11555_17360# a_11555_17360# VSS.t278 nfet_03v3 ad=0.39p pd=2.02u as=0.39p ps=2.02u w=1.5u l=0.5u
X33 VSS.t293 a_11555_17360# a_11555_17360# VSS.t292 nfet_03v3 ad=0.39p pd=2.02u as=0.39p ps=2.02u w=1.5u l=0.5u
X34 VSS.t259 voltage_reference_0.v_1_25 VSS.t258 ppolyf_u_1k r_width=3u r_length=20u
X35 tanh_ota_0.V_in_n tanh_ota_0.V_ref a_8559_11644# VSS.t56 nfet_03v3 ad=0.65p pd=3.02u as=0.65p ps=3.02u w=2.5u l=0.5u
X36 tanh_ota_0.V_in_p VSS.t185 VSS.t186 VSS.t116 nfet_03v3 ad=0.65p pd=3.02u as=1.525p ps=6.22u w=2.5u l=0.5u
X37 a_7766_18788# tanh_ota_0.V_in_p a_10295_19296# VSS.t107 nfet_03v3 ad=1.3p pd=5.52u as=1.3p ps=5.52u w=5u l=0.5u
X38 VSS.t244 VSS.t243 a_13382_5774# VSS.t238 nfet_03v3 ad=1.525p pd=6.22u as=0.65p ps=3.02u w=2.5u l=2u
X39 VDD.t25 a_13492_24053# voltage_reference_0.v_1_25 VSS.t91 nfet_03v3 ad=2.6p pd=10.52u as=2.6p ps=10.52u w=10u l=1u
X40 a_8355_9194# tanh_ota_0.V_ref tanh_ota_0.V_in_p VSS.t57 nfet_03v3 ad=0.65p pd=3.02u as=0.65p ps=3.02u w=2.5u l=0.5u
X41 tanh_ota_0.V_in_n tanh_ota_0.V_ref a_8559_11644# VSS.t61 nfet_03v3 ad=0.65p pd=3.02u as=0.65p ps=3.02u w=2.5u l=0.5u
X42 VDD.t16 a_7766_18788# a_7766_18788# VDD.t15 pfet_03v3 ad=1.3p pd=5.52u as=1.3p ps=5.52u w=5u l=0.5u
X43 a_8355_9194# V_b.t15 tanh_ota_0.V_in_n VSS.t60 nfet_03v3 ad=0.65p pd=3.02u as=0.65p ps=3.02u w=2.5u l=0.5u
X44 VSS.t152 VSS.t151 a_3415_21020# VSS.t88 nfet_03v3 ad=3.05p pd=11.22u as=1.3p ps=5.52u w=5u l=0.5u
X45 a_23777_13400# a_19854_15770# a_22199_13400# VDD.t35 pfet_03v3 ad=2.6p pd=10.52u as=2.6p ps=10.52u w=10u l=1u
X46 VSS.t26 a_13250_5878# a_13382_5774# VSS.t25 nfet_03v3 ad=0.65p pd=3.02u as=0.65p ps=3.02u w=2.5u l=2u
X47 a_3415_6100# VSS.t220 VSS.t221 VSS.t211 nfet_03v3 ad=1.3p pd=5.52u as=3.05p ps=11.22u w=5u l=0.5u
X48 a_3619_22696# V_w1.t2 tanh_ota_0.V_in_n VSS.t47 nfet_03v3 ad=0.65p pd=3.02u as=0.65p ps=3.02u w=2.5u l=0.5u
X49 a_2717_18262# gilbert_multiplier_current_2.V_x_n a_3415_21020# VSS.t88 nfet_03v3 ad=1.3p pd=5.52u as=1.3p ps=5.52u w=5u l=0.5u
X50 a_3619_2602# tanh_ota_0.V_ref tanh_ota_0.V_in_p VSS.t83 nfet_03v3 ad=0.65p pd=3.02u as=0.65p ps=3.02u w=2.5u l=0.5u
X51 a_3619_22696# tanh_ota_0.V_ref tanh_ota_0.V_in_p VSS.t47 nfet_03v3 ad=0.65p pd=3.02u as=0.65p ps=3.02u w=2.5u l=0.5u
X52 VDD.t56 a_13492_1131# tanh_ota_0.V_ref VSS.t313 nfet_03v3 ad=2.6p pd=10.52u as=2.6p ps=10.52u w=10u l=1u
X53 a_3415_21020# tanh_ota_0.V_ref tanh_ota_0.V_in_n VSS.t45 nfet_03v3 ad=0.65p pd=3.02u as=0.65p ps=3.02u w=2.5u l=0.5u
X54 VSS.t267 a_11555_17360# a_11555_17360# VSS.t266 nfet_03v3 ad=0.39p pd=2.02u as=0.39p ps=2.02u w=1.5u l=0.5u
X55 VSS.t163 VSS.t161 a_13382_20226# VSS.t162 nfet_03v3 ad=1.525p pd=6.22u as=0.65p ps=3.02u w=2.5u l=2u
X56 VSS.t30 a_13250_5878# a_13382_5774# VSS.t29 nfet_03v3 ad=0.65p pd=3.02u as=0.65p ps=3.02u w=2.5u l=2u
X57 VSS.t209 VSS.t208 a_8559_11644# VSS.t103 nfet_03v3 ad=3.05p pd=11.22u as=1.3p ps=5.52u w=5u l=0.5u
X58 a_3415_21020# V_w1.t11 tanh_ota_0.V_in_p VSS.t45 nfet_03v3 ad=0.65p pd=3.02u as=0.65p ps=3.02u w=2.5u l=0.5u
X59 a_3415_21020# V_w1.t4 tanh_ota_0.V_in_p VSS.t46 nfet_03v3 ad=0.65p pd=3.02u as=0.65p ps=3.02u w=2.5u l=0.5u
X60 gilbert_multiplier_current_2.V_x_n voltage_reference_0.v_1_25 I_x1.t0 VSS.t260 nfet_03v3 ad=0.65p pd=3.02u as=1.525p ps=6.22u w=2.5u l=0.5u
X61 a_3415_6100# tanh_ota_0.V_ref tanh_ota_0.V_in_n VSS.t7 nfet_03v3 ad=0.65p pd=3.02u as=0.65p ps=3.02u w=2.5u l=0.5u
X62 VDD.t47 a_11839_24980# VSS.t264 ppolyf_u_1k r_width=3u r_length=22u
X63 a_3415_21020# tanh_ota_0.V_ref tanh_ota_0.V_in_n VSS.t46 nfet_03v3 ad=0.65p pd=3.02u as=0.65p ps=3.02u w=2.5u l=0.5u
X64 VSS.t17 a_13250_5878# a_13382_20226# VSS.t16 nfet_03v3 ad=0.65p pd=3.02u as=0.65p ps=3.02u w=2.5u l=2u
X65 a_21914_17004# a_26642_17856# VSS.t9 ppolyf_u_1k r_width=3u r_length=23u
X66 a_14558_5878# a_19467_13334# VSS.t304 ppolyf_u_1k r_width=3u r_length=20u
X67 tanh_ota_0.V_ref a_13492_1131# VDD.t49 VSS.t306 nfet_03v3 ad=2.6p pd=10.52u as=2.6p ps=10.52u w=10u l=1u
X68 a_10295_19296# a_11555_17360# VSS.t283 VSS.t4 nfet_03v3 ad=0.39p pd=2.02u as=0.39p ps=2.02u w=1.5u l=0.5u
X69 VDD.t6 a_19458_12220# a_22199_13400# VDD.t4 pfet_03v3 ad=1.3p pd=5.52u as=1.3p ps=5.52u w=5u l=1u
X70 a_3619_2602# voltage_reference_0.v_1_25 a_3598_8020# VSS.t82 nfet_03v3 ad=1.3p pd=5.52u as=1.3p ps=5.52u w=5u l=0.5u
X71 V_out_perceptron.t6 a_8953_14522# VSS.t87 ppolyf_u_1k r_width=3u r_length=15u
X72 a_3598_8020# tanh_ota_0.V_ref VSS.t72 VSS.t71 nfet_03v3 ad=1.04p pd=4.52u as=1.04p ps=4.52u w=4u l=1u
X73 a_11555_17360# a_11555_17360# VSS.t299 VSS.t298 nfet_03v3 ad=0.39p pd=2.02u as=0.39p ps=2.02u w=1.5u l=0.5u
X74 VSS.t174 VSS.t173 a_14690_20226# VSS.t162 nfet_03v3 ad=3.05p pd=11.22u as=1.3p ps=5.52u w=5u l=2u
X75 tanh_ota_0.V_in_p V_b.t8 a_8559_11644# VSS.t59 nfet_03v3 ad=0.65p pd=3.02u as=0.65p ps=3.02u w=2.5u l=0.5u
X76 tanh_ota_0.V_in_p tanh_ota_0.V_ref a_3619_2602# VSS.t84 nfet_03v3 ad=0.65p pd=3.02u as=0.65p ps=3.02u w=2.5u l=0.5u
X77 a_3619_2602# V_w2.t14 tanh_ota_0.V_in_n VSS.t83 nfet_03v3 ad=0.65p pd=3.02u as=0.65p ps=3.02u w=2.5u l=0.5u
X78 VSS.t53 tanh_ota_0.V_ref a_2717_18262# VSS.t52 nfet_03v3 ad=1.04p pd=4.52u as=1.04p ps=4.52u w=4u l=1u
X79 tanh_ota_0.V_in_n tanh_ota_0.V_ref a_8559_11644# VSS.t59 nfet_03v3 ad=0.65p pd=3.02u as=0.65p ps=3.02u w=2.5u l=0.5u
X80 a_8355_9194# VSS.t204 VSS.t205 VSS.t116 nfet_03v3 ad=1.3p pd=5.52u as=3.05p ps=11.22u w=5u l=0.5u
X81 a_3415_6100# V_w2.t8 tanh_ota_0.V_in_p VSS.t85 nfet_03v3 ad=0.65p pd=3.02u as=0.65p ps=3.02u w=2.5u l=0.5u
X82 a_7311_22424# a_11839_23276# VSS.t0 ppolyf_u_1k r_width=3u r_length=22u
X83 voltage_reference_0.v_1_25 a_13492_24053# VDD.t34 VSS.t100 nfet_03v3 ad=2.6p pd=10.52u as=2.6p ps=10.52u w=10u l=1u
X84 a_7766_18788# a_7766_18788# VDD.t10 VDD.t9 pfet_03v3 ad=1.3p pd=5.52u as=1.3p ps=5.52u w=5u l=0.5u
X85 a_13382_20226# voltage_reference_0.v_1_25 a_13492_24053# VSS.t16 nfet_03v3 ad=1.3p pd=5.52u as=1.3p ps=5.52u w=5u l=2u
X86 tanh_ota_0.V_in_p V_b.t7 a_8559_11644# VSS.t56 nfet_03v3 ad=0.65p pd=3.02u as=0.65p ps=3.02u w=2.5u l=0.5u
X87 tanh_ota_0.V_in_n V_w2.t2 a_3619_2602# VSS.t80 nfet_03v3 ad=0.65p pd=3.02u as=0.65p ps=3.02u w=2.5u l=0.5u
X88 VSS.t297 a_11555_17360# a_11555_17360# VSS.t296 nfet_03v3 ad=0.39p pd=2.02u as=0.39p ps=2.02u w=1.5u l=0.5u
X89 tanh_ota_0.V_in_n VSS.t118 VSS.t119 VSS.t116 nfet_03v3 ad=0.65p pd=3.02u as=1.525p ps=6.22u w=2.5u l=0.5u
X90 a_3415_6100# tanh_ota_0.V_ref tanh_ota_0.V_in_n VSS.t83 nfet_03v3 ad=0.65p pd=3.02u as=0.65p ps=3.02u w=2.5u l=0.5u
X91 VDD.t27 a_13492_24053# voltage_reference_0.v_1_25 VSS.t93 nfet_03v3 ad=2.6p pd=10.52u as=2.6p ps=10.52u w=10u l=1u
X92 a_13250_5878# a_13250_5878# VSS.t14 VSS.t13 nfet_03v3 ad=1.3p pd=5.52u as=1.3p ps=5.52u w=5u l=1u
X93 tanh_ota_0.V_in_p tanh_ota_0.V_ref a_8355_9194# VSS.t61 nfet_03v3 ad=0.65p pd=3.02u as=0.65p ps=3.02u w=2.5u l=0.5u
X94 a_8559_11644# voltage_reference_0.v_1_15 a_9196_7474# VSS.t103 nfet_03v3 ad=1.3p pd=5.52u as=1.3p ps=5.52u w=5u l=0.5u
X95 VDD.t66 VDD.t64 a_7766_18788# VDD.t65 pfet_03v3 ad=3.25p pd=11.3u as=1.3p ps=5.52u w=5u l=0.5u
X96 VSS.t219 VSS.t218 a_3619_2602# VSS.t214 nfet_03v3 ad=3.05p pd=11.22u as=1.3p ps=5.52u w=5u l=0.5u
X97 tanh_ota_0.V_in_n V_w1.t14 a_3619_22696# VSS.t44 nfet_03v3 ad=0.65p pd=3.02u as=0.65p ps=3.02u w=2.5u l=0.5u
X98 VSS.t160 VSS.t158 a_3598_19300# VSS.t159 nfet_03v3 ad=2.44p pd=9.22u as=1.04p ps=4.52u w=4u l=1u
X99 tanh_ota_0.V_in_n V_w2.t13 a_3619_2602# VSS.t84 nfet_03v3 ad=0.65p pd=3.02u as=0.65p ps=3.02u w=2.5u l=0.5u
X100 VSS.t284 a_11555_17360# a_11555_17360# VSS.t126 nfet_03v3 ad=0.39p pd=2.02u as=0.39p ps=2.02u w=1.5u l=0.5u
X101 a_13382_20226# a_13250_5878# VSS.t15 VSS.t11 nfet_03v3 ad=0.65p pd=3.02u as=0.65p ps=3.02u w=2.5u l=2u
X102 a_19914_7960# VDD.t93 VSS.t35 ppolyf_u_1k r_width=3u r_length=33u
X103 a_3415_21020# V_w1.t6 tanh_ota_0.V_in_p VSS.t46 nfet_03v3 ad=0.65p pd=3.02u as=0.65p ps=3.02u w=2.5u l=0.5u
X104 a_19458_12220# VDD.t61 VDD.t63 VDD.t62 pfet_03v3 ad=1.3p pd=5.52u as=3.25p ps=11.3u w=5u l=1u
X105 a_13382_5774# a_13250_5878# VSS.t24 VSS.t23 nfet_03v3 ad=0.65p pd=3.02u as=0.65p ps=3.02u w=2.5u l=2u
X106 a_3415_21020# tanh_ota_0.V_ref tanh_ota_0.V_in_n VSS.t46 nfet_03v3 ad=0.65p pd=3.02u as=0.65p ps=3.02u w=2.5u l=0.5u
X107 voltage_reference_0.v_1_25 a_13492_24053# VDD.t30 VSS.t96 nfet_03v3 ad=2.6p pd=10.52u as=2.6p ps=10.52u w=10u l=1u
X108 a_14690_20226# VDD.t73 VDD.t75 VDD.t74 pfet_03v3 ad=2.6p pd=10.52u as=6.5p ps=21.3u w=10u l=2u
X109 VSS.t41 a_23777_13400# a_23777_13400# VSS.t40 nfet_03v3 ad=1.3p pd=5.52u as=1.3p ps=5.52u w=5u l=1u
X110 tanh_ota_0.V_in_p tanh_ota_0.V_ref a_3619_2602# VSS.t80 nfet_03v3 ad=0.65p pd=3.02u as=0.65p ps=3.02u w=2.5u l=0.5u
X111 a_13382_20226# a_13250_5878# VSS.t19 VSS.t18 nfet_03v3 ad=0.65p pd=3.02u as=0.65p ps=3.02u w=2.5u l=2u
X112 I_x2.t1 voltage_reference_0.v_1_25 gilbert_multiplier_current_1.V_x_n VSS.t261 nfet_03v3 ad=1.525p pd=6.22u as=0.65p ps=3.02u w=2.5u l=0.5u
X113 a_13382_5774# a_13250_5878# VSS.t28 VSS.t27 nfet_03v3 ad=0.65p pd=3.02u as=0.65p ps=3.02u w=2.5u l=2u
X114 tanh_ota_0.V_in_n tanh_ota_0.V_ref a_3415_6100# VSS.t84 nfet_03v3 ad=0.65p pd=3.02u as=0.65p ps=3.02u w=2.5u l=0.5u
X115 a_13382_5774# VSS.t245 VSS.t246 VSS.t241 nfet_03v3 ad=0.65p pd=3.02u as=1.525p ps=6.22u w=2.5u l=2u
X116 tanh_ota_0.V_in_p V_w2.t6 a_3415_6100# VSS.t80 nfet_03v3 ad=0.65p pd=3.02u as=0.65p ps=3.02u w=2.5u l=0.5u
X117 VDD.t80 VDD.t79 a_22199_13400# VDD.t4 pfet_03v3 ad=3.25p pd=11.3u as=1.3p ps=5.52u w=5u l=1u
X118 a_14558_5878# a_26642_10516# VSS.t35 ppolyf_u_1k r_width=3u r_length=33u
X119 a_14690_20226# a_14558_20330# a_13382_20226# VSS.t11 nfet_03v3 ad=1.3p pd=5.52u as=1.3p ps=5.52u w=5u l=2u
X120 tanh_ota_0.V_in_n tanh_ota_0.V_ref a_8559_11644# VSS.t63 nfet_03v3 ad=0.65p pd=3.02u as=0.65p ps=3.02u w=2.5u l=0.5u
X121 tanh_ota_0.V_in_p V_b.t5 a_8559_11644# VSS.t63 nfet_03v3 ad=0.65p pd=3.02u as=0.65p ps=3.02u w=2.5u l=0.5u
X122 VDD.t54 a_13492_1131# tanh_ota_0.V_ref VSS.t311 nfet_03v3 ad=2.6p pd=10.52u as=2.6p ps=10.52u w=10u l=1u
X123 a_10295_19296# tanh_ota_0.V_in_n V_out_perceptron.t0 VSS.t3 nfet_03v3 ad=1.3p pd=5.52u as=1.3p ps=5.52u w=5u l=0.5u
X124 a_13492_24053# voltage_reference_0.v_1_25 a_13382_20226# VSS.t18 nfet_03v3 ad=1.3p pd=5.52u as=1.3p ps=5.52u w=5u l=2u
X125 a_13330_16152# a_19458_15300# VSS.t10 ppolyf_u_1k r_width=3u r_length=30u
X126 tanh_ota_0.V_in_n V_b.t14 a_8355_9194# VSS.t61 nfet_03v3 ad=0.65p pd=3.02u as=0.65p ps=3.02u w=2.5u l=0.5u
X127 tanh_ota_0.V_in_n V_b.t3 a_8355_9194# VSS.t56 nfet_03v3 ad=0.65p pd=3.02u as=0.65p ps=3.02u w=2.5u l=0.5u
X128 a_3415_6100# gilbert_multiplier_current_1.V_x_n a_2717_9730# VSS.t8 nfet_03v3 ad=1.3p pd=5.52u as=1.3p ps=5.52u w=5u l=0.5u
X129 a_7766_18788# a_7766_18788# VDD.t18 VDD.t17 pfet_03v3 ad=1.3p pd=5.52u as=1.3p ps=5.52u w=5u l=0.5u
X130 VSS.t271 a_11555_17360# a_11555_17360# VSS.t270 nfet_03v3 ad=0.39p pd=2.02u as=0.39p ps=2.02u w=1.5u l=0.5u
X131 VSS.t286 a_11555_17360# a_11555_17360# VSS.t108 nfet_03v3 ad=0.39p pd=2.02u as=0.39p ps=2.02u w=1.5u l=0.5u
X132 tanh_ota_0.V_in_p VSS.t189 VSS.t190 VSS.t116 nfet_03v3 ad=0.65p pd=3.02u as=1.525p ps=6.22u w=2.5u l=0.5u
X133 VSS.t253 VSS.t251 VDD.t60 VSS.t252 nfet_03v3 ad=6.1p pd=21.22u as=2.6p ps=10.52u w=10u l=1u
X134 voltage_reference_0.v_1_25 a_13492_24053# VDD.t32 VSS.t98 nfet_03v3 ad=2.6p pd=10.52u as=2.6p ps=10.52u w=10u l=1u
X135 tanh_ota_0.V_in_p tanh_ota_0.V_ref a_3619_22696# VSS.t44 nfet_03v3 ad=0.65p pd=3.02u as=0.65p ps=3.02u w=2.5u l=0.5u
X136 tanh_ota_0.V_in_p tanh_ota_0.V_ref a_3619_22696# VSS.t47 nfet_03v3 ad=0.65p pd=3.02u as=0.65p ps=3.02u w=2.5u l=0.5u
X137 a_22199_13400# a_19458_12220# VDD.t7 VDD.t4 pfet_03v3 ad=1.3p pd=5.52u as=1.3p ps=5.52u w=5u l=1u
X138 a_3415_6100# V_w2.t10 tanh_ota_0.V_in_p VSS.t83 nfet_03v3 ad=0.65p pd=3.02u as=0.65p ps=3.02u w=2.5u l=0.5u
X139 tanh_ota_0.V_in_n VSS.t109 VSS.t110 VSS.t44 nfet_03v3 ad=0.65p pd=3.02u as=1.525p ps=6.22u w=2.5u l=0.5u
X140 a_2717_12168# a_2717_9730# VSS.t32 ppolyf_u_1k r_width=3u r_length=11.55u
X141 tanh_ota_0.V_in_p V_w1.t10 a_3415_21020# VSS.t45 nfet_03v3 ad=0.65p pd=3.02u as=0.65p ps=3.02u w=2.5u l=0.5u
X142 a_9805_17650# tanh_ota_0.V_ref VSS.t87 ppolyf_u_1k r_width=3u r_length=15u
X143 tanh_ota_0.V_in_n VSS.t247 VSS.t248 VSS.t211 nfet_03v3 ad=0.65p pd=3.02u as=1.525p ps=6.22u w=2.5u l=0.5u
X144 VSS.t79 tanh_ota_0.V_ref a_9196_7474# VSS.t75 nfet_03v3 ad=1.04p pd=4.52u as=1.04p ps=4.52u w=4u l=1u
X145 a_11555_17360# a_11555_17360# VSS.t269 VSS.t268 nfet_03v3 ad=0.39p pd=2.02u as=0.39p ps=2.02u w=1.5u l=0.5u
X146 a_2717_9730# tanh_ota_0.V_ref VSS.t66 VSS.t65 nfet_03v3 ad=1.04p pd=4.52u as=1.04p ps=4.52u w=4u l=1u
X147 VSS.t203 VSS.t201 a_3598_8020# VSS.t202 nfet_03v3 ad=2.44p pd=9.22u as=1.04p ps=4.52u w=4u l=1u
X148 VDD.t50 a_13492_1131# tanh_ota_0.V_ref VSS.t307 nfet_03v3 ad=2.6p pd=10.52u as=2.6p ps=10.52u w=10u l=1u
X149 a_13330_9664# a_19458_8812# VSS.t320 ppolyf_u_1k r_width=3u r_length=30u
X150 VDD.t46 VSS.t146 VSS.t148 VSS.t147 nfet_03v3 ad=2.6p pd=10.52u as=6.1p ps=21.22u w=10u l=1u
X151 a_13330_11368# a_19458_12220# VSS.t90 ppolyf_u_1k r_width=3u r_length=30u
X152 a_8355_9194# voltage_reference_0.v_1_25 a_7657_6436# VSS.t56 nfet_03v3 ad=1.3p pd=5.52u as=1.3p ps=5.52u w=5u l=0.5u
X153 tanh_ota_0.V_in_n V_w2.t0 a_3619_2602# VSS.t82 nfet_03v3 ad=0.65p pd=3.02u as=0.65p ps=3.02u w=2.5u l=0.5u
X154 VSS.t301 a_11555_17360# a_11555_17360# VSS.t300 nfet_03v3 ad=0.39p pd=2.02u as=0.39p ps=2.02u w=1.5u l=0.5u
X155 voltage_reference_0.v_1_25 a_13492_24053# VDD.t28 VSS.t94 nfet_03v3 ad=2.6p pd=10.52u as=2.6p ps=10.52u w=10u l=1u
X156 VSS.t22 a_13250_5878# a_13250_5878# VSS.t21 nfet_03v3 ad=1.3p pd=5.52u as=1.3p ps=5.52u w=5u l=1u
X157 tanh_ota_0.V_in_p V_w2.t9 a_3415_6100# VSS.t84 nfet_03v3 ad=0.65p pd=3.02u as=0.65p ps=3.02u w=2.5u l=0.5u
X158 VDD.t12 a_7766_18788# V_out_perceptron.t2 VDD.t11 pfet_03v3 ad=1.3p pd=5.52u as=1.3p ps=5.52u w=5u l=0.5u
X159 a_22199_13400# a_19854_15770# a_23777_13400# VDD.t35 pfet_03v3 ad=2.6p pd=10.52u as=2.6p ps=10.52u w=10u l=1u
X160 tanh_ota_0.V_in_p VSS.t210 VSS.t212 VSS.t211 nfet_03v3 ad=0.65p pd=3.02u as=1.525p ps=6.22u w=2.5u l=0.5u
X161 VSS.t20 a_13250_5878# a_13382_20226# VSS.t12 nfet_03v3 ad=0.65p pd=3.02u as=0.65p ps=3.02u w=2.5u l=2u
X162 a_21914_17004# a_26642_16152# VSS.t9 ppolyf_u_1k r_width=3u r_length=23u
X163 tanh_ota_0.V_in_p tanh_ota_0.V_ref a_8355_9194# VSS.t56 nfet_03v3 ad=0.65p pd=3.02u as=0.65p ps=3.02u w=2.5u l=0.5u
X164 tanh_ota_0.V_in_p tanh_ota_0.V_ref a_8355_9194# VSS.t64 nfet_03v3 ad=0.65p pd=3.02u as=0.65p ps=3.02u w=2.5u l=0.5u
X165 tanh_ota_0.V_in_n tanh_ota_0.V_ref a_3415_6100# VSS.t80 nfet_03v3 ad=0.65p pd=3.02u as=0.65p ps=3.02u w=2.5u l=0.5u
X166 a_7311_22424# a_11555_17360# VSS.t34 ppolyf_u_1k r_width=3u r_length=22u
X167 tanh_ota_0.V_in_n VSS.t115 VSS.t117 VSS.t116 nfet_03v3 ad=0.65p pd=3.02u as=1.525p ps=6.22u w=2.5u l=0.5u
X168 tanh_ota_0.V_in_n V_b.t1 a_8355_9194# VSS.t64 nfet_03v3 ad=0.65p pd=3.02u as=0.65p ps=3.02u w=2.5u l=0.5u
X169 VSS.t239 VSS.t237 a_14690_5774# VSS.t238 nfet_03v3 ad=3.05p pd=11.22u as=1.3p ps=5.52u w=5u l=2u
X170 a_19914_9664# a_26642_8812# VSS.t35 ppolyf_u_1k r_width=3u r_length=33u
X171 tanh_ota_0.V_in_n V_w1.t12 a_3619_22696# VSS.t44 nfet_03v3 ad=0.65p pd=3.02u as=0.65p ps=3.02u w=2.5u l=0.5u
X172 a_19458_12220# a_19458_12220# VDD.t1 VDD.t0 pfet_03v3 ad=1.3p pd=5.52u as=1.3p ps=5.52u w=5u l=1u
X173 tanh_ota_0.V_in_p tanh_ota_0.V_ref a_3619_22696# VSS.t44 nfet_03v3 ad=0.65p pd=3.02u as=0.65p ps=3.02u w=2.5u l=0.5u
X174 tanh_ota_0.V_in_n V_w1.t3 a_3619_22696# VSS.t47 nfet_03v3 ad=0.65p pd=3.02u as=0.65p ps=3.02u w=2.5u l=0.5u
X175 a_3415_21020# gilbert_multiplier_current_2.V_x_n a_2717_18262# VSS.t88 nfet_03v3 ad=1.3p pd=5.52u as=1.3p ps=5.52u w=5u l=0.5u
X176 VSS.t39 a_23777_13400# voltage_reference_0.v_1_15 VSS.t38 nfet_03v3 ad=1.3p pd=5.52u as=1.3p ps=5.52u w=5u l=1u
X177 tanh_ota_0.V_in_p VSS.t233 VSS.t234 VSS.t211 nfet_03v3 ad=0.65p pd=3.02u as=1.525p ps=6.22u w=2.5u l=0.5u
X178 tanh_ota_0.V_in_p VSS.t139 VSS.t140 VSS.t47 nfet_03v3 ad=0.65p pd=3.02u as=1.525p ps=6.22u w=2.5u l=0.5u
X179 a_3415_21020# VSS.t149 VSS.t150 VSS.t88 nfet_03v3 ad=1.3p pd=5.52u as=3.05p ps=11.22u w=5u l=0.5u
X180 VSS.t49 tanh_ota_0.V_ref a_3598_19300# VSS.t48 nfet_03v3 ad=1.04p pd=4.52u as=1.04p ps=4.52u w=4u l=1u
X181 VDD.t52 a_13492_1131# tanh_ota_0.V_ref VSS.t309 nfet_03v3 ad=2.6p pd=10.52u as=2.6p ps=10.52u w=10u l=1u
X182 a_13382_5774# tanh_ota_0.V_ref a_13492_1131# VSS.t25 nfet_03v3 ad=1.3p pd=5.52u as=1.3p ps=5.52u w=5u l=2u
X183 tanh_ota_0.V_in_p tanh_ota_0.V_ref a_3619_2602# VSS.t82 nfet_03v3 ad=0.65p pd=3.02u as=0.65p ps=3.02u w=2.5u l=0.5u
X184 tanh_ota_0.V_in_n tanh_ota_0.V_ref a_3415_21020# VSS.t45 nfet_03v3 ad=0.65p pd=3.02u as=0.65p ps=3.02u w=2.5u l=0.5u
X185 a_13330_17856# a_19458_17004# VSS.t105 ppolyf_u_1k r_width=3u r_length=30u
X186 a_22199_13400# VDD.t81 VDD.t82 VDD.t4 pfet_03v3 ad=1.3p pd=5.52u as=3.25p ps=11.3u w=5u l=1u
X187 tanh_ota_0.V_in_p VSS.t133 VSS.t134 VSS.t45 nfet_03v3 ad=0.65p pd=3.02u as=1.525p ps=6.22u w=2.5u l=0.5u
X188 VSS.t275 a_11555_17360# a_11555_17360# VSS.t274 nfet_03v3 ad=0.39p pd=2.02u as=0.39p ps=2.02u w=1.5u l=0.5u
X189 VSS.t250 VSS.t249 tanh_ota_0.V_in_n VSS.t214 nfet_03v3 ad=1.525p pd=6.22u as=0.65p ps=3.02u w=2.5u l=0.5u
X190 a_13382_5774# a_14558_5878# a_14690_5774# VSS.t29 nfet_03v3 ad=1.3p pd=5.52u as=1.3p ps=5.52u w=5u l=2u
X191 tanh_ota_0.V_in_n tanh_ota_0.V_ref a_3415_21020# VSS.t46 nfet_03v3 ad=0.65p pd=3.02u as=0.65p ps=3.02u w=2.5u l=0.5u
X192 VSS.t289 a_11555_17360# a_11555_17360# VSS.t288 nfet_03v3 ad=0.39p pd=2.02u as=0.39p ps=2.02u w=1.5u l=0.5u
X193 a_13382_20226# a_14558_20330# a_14690_20226# VSS.t12 nfet_03v3 ad=1.3p pd=5.52u as=1.3p ps=5.52u w=5u l=2u
X194 tanh_ota_0.V_in_p V_w2.t4 a_3415_6100# VSS.t82 nfet_03v3 ad=0.65p pd=3.02u as=0.65p ps=3.02u w=2.5u l=0.5u
X195 VSS.t74 tanh_ota_0.V_ref a_7657_6436# VSS.t73 nfet_03v3 ad=1.04p pd=4.52u as=1.04p ps=4.52u w=4u l=1u
X196 VDD.t20 a_7766_18788# V_out_perceptron.t3 VDD.t19 pfet_03v3 ad=1.3p pd=5.52u as=1.3p ps=5.52u w=5u l=0.5u
X197 a_7657_6436# a_7657_3998# VSS.t321 ppolyf_u_1k r_width=3u r_length=11.55u
X198 a_8559_11644# tanh_ota_0.V_ref tanh_ota_0.V_in_n VSS.t59 nfet_03v3 ad=0.65p pd=3.02u as=0.65p ps=3.02u w=2.5u l=0.5u
X199 tanh_ota_0.V_ref a_13492_1131# VDD.t55 VSS.t312 nfet_03v3 ad=2.6p pd=10.52u as=2.6p ps=10.52u w=10u l=1u
X200 a_11555_17360# a_11555_17360# VSS.t287 VSS.t129 nfet_03v3 ad=0.39p pd=2.02u as=0.39p ps=2.02u w=1.5u l=0.5u
X201 a_8559_11644# V_b.t9 tanh_ota_0.V_in_p VSS.t62 nfet_03v3 ad=0.65p pd=3.02u as=0.65p ps=3.02u w=2.5u l=0.5u
X202 a_3598_8020# VSS.t198 VSS.t200 VSS.t199 nfet_03v3 ad=1.04p pd=4.52u as=2.44p ps=9.22u w=4u l=1u
X203 VDD.t48 a_13492_1131# tanh_ota_0.V_ref VSS.t305 nfet_03v3 ad=2.6p pd=10.52u as=2.6p ps=10.52u w=10u l=1u
X204 tanh_ota_0.V_in_n V_b.t12 a_8355_9194# VSS.t58 nfet_03v3 ad=0.65p pd=3.02u as=0.65p ps=3.02u w=2.5u l=0.5u
X205 VSS.t215 VSS.t213 tanh_ota_0.V_in_p VSS.t214 nfet_03v3 ad=1.525p pd=6.22u as=0.65p ps=3.02u w=2.5u l=0.5u
X206 tanh_ota_0.V_in_p tanh_ota_0.V_ref a_8355_9194# VSS.t58 nfet_03v3 ad=0.65p pd=3.02u as=0.65p ps=3.02u w=2.5u l=0.5u
X207 a_22199_13400# a_19458_12220# VDD.t5 VDD.t4 pfet_03v3 ad=1.3p pd=5.52u as=1.3p ps=5.52u w=5u l=1u
X208 a_19914_9664# a_26642_10516# VSS.t35 ppolyf_u_1k r_width=3u r_length=33u
X209 a_3619_22696# voltage_reference_0.v_1_25 a_3598_19300# VSS.t88 nfet_03v3 ad=1.3p pd=5.52u as=1.3p ps=5.52u w=5u l=0.5u
X210 VDD.t45 tanh_ota_0.V_in_n VSS.t33 ppolyf_u_1k r_width=3u r_length=7.3u
X211 V_out_perceptron.t1 tanh_ota_0.V_in_n a_10295_19296# VSS.t4 nfet_03v3 ad=1.3p pd=5.52u as=1.3p ps=5.52u w=5u l=0.5u
X212 a_2717_9730# gilbert_multiplier_current_1.V_x_n a_3415_6100# VSS.t7 nfet_03v3 ad=1.3p pd=5.52u as=1.3p ps=5.52u w=5u l=0.5u
X213 tanh_ota_0.V_in_p tanh_ota_0.V_ref a_3619_22696# VSS.t47 nfet_03v3 ad=0.65p pd=3.02u as=0.65p ps=3.02u w=2.5u l=0.5u
X214 a_3619_22696# VSS.t153 VSS.t154 VSS.t88 nfet_03v3 ad=1.3p pd=5.52u as=3.05p ps=11.22u w=5u l=0.5u
X215 tanh_ota_0.V_in_n V_w1.t1 a_3619_22696# VSS.t47 nfet_03v3 ad=0.65p pd=3.02u as=0.65p ps=3.02u w=2.5u l=0.5u
X216 a_11555_17360# a_11555_17360# VSS.t273 VSS.t272 nfet_03v3 ad=0.39p pd=2.02u as=0.39p ps=2.02u w=1.5u l=0.5u
X217 VSS.t236 VSS.t235 tanh_ota_0.V_in_p VSS.t214 nfet_03v3 ad=1.525p pd=6.22u as=0.65p ps=3.02u w=2.5u l=0.5u
X218 tanh_ota_0.V_in_p V_w1.t8 a_3415_21020# VSS.t45 nfet_03v3 ad=0.65p pd=3.02u as=0.65p ps=3.02u w=2.5u l=0.5u
X219 a_13250_5878# a_19458_15300# VSS.t86 ppolyf_u_1k r_width=3u r_length=30u
X220 tanh_ota_0.V_in_n tanh_ota_0.V_ref a_3415_21020# VSS.t45 nfet_03v3 ad=0.65p pd=3.02u as=0.65p ps=3.02u w=2.5u l=0.5u
X221 VDD.t72 VDD.t70 a_14690_20226# VDD.t71 pfet_03v3 ad=6.5p pd=21.3u as=2.6p ps=10.52u w=10u l=2u
X222 a_21914_18708# a_26642_17856# VSS.t9 ppolyf_u_1k r_width=3u r_length=23u
X223 tanh_ota_0.V_in_p tanh_ota_0.V_ref a_3619_2602# VSS.t8 nfet_03v3 ad=0.65p pd=3.02u as=0.65p ps=3.02u w=2.5u l=0.5u
X224 VDD.t33 a_13492_24053# voltage_reference_0.v_1_25 VSS.t99 nfet_03v3 ad=2.6p pd=10.52u as=2.6p ps=10.52u w=10u l=1u
X225 a_11555_17360# a_11555_17360# VSS.t285 VSS.t107 nfet_03v3 ad=0.39p pd=2.02u as=0.39p ps=2.02u w=1.5u l=0.5u
X226 VSS.t188 VSS.t187 tanh_ota_0.V_in_p VSS.t59 nfet_03v3 ad=1.525p pd=6.22u as=0.65p ps=3.02u w=2.5u l=0.5u
X227 a_7657_6436# tanh_ota_0.V_ref VSS.t76 VSS.t75 nfet_03v3 ad=1.04p pd=4.52u as=1.04p ps=4.52u w=4u l=1u
X228 tanh_ota_0.V_in_p V_w1.t7 a_3415_21020# VSS.t46 nfet_03v3 ad=0.65p pd=3.02u as=0.65p ps=3.02u w=2.5u l=0.5u
X229 a_13330_11368# a_19458_10516# VSS.t106 ppolyf_u_1k r_width=3u r_length=30u
X230 tanh_ota_0.V_in_n VSS.t229 VSS.t230 VSS.t211 nfet_03v3 ad=0.65p pd=3.02u as=1.525p ps=6.22u w=2.5u l=0.5u
X231 tanh_ota_0.V_in_n VSS.t113 VSS.t114 VSS.t46 nfet_03v3 ad=0.65p pd=3.02u as=1.525p ps=6.22u w=2.5u l=0.5u
X232 voltage_reference_0.v_1_25 a_13492_24053# VDD.t26 VSS.t92 nfet_03v3 ad=2.6p pd=10.52u as=2.6p ps=10.52u w=10u l=1u
X233 VSS.t172 VSS.t170 VSS.t172 VSS.t171 nfet_03v3 ad=0.39p pd=2.02u as=0 ps=0 w=1.5u l=0.5u
X234 VDD.t40 a_14690_20226# a_13492_24053# VDD.t39 pfet_03v3 ad=2.6p pd=10.52u as=2.6p ps=10.52u w=10u l=2u
X235 a_21914_18708# VSS.t263 VSS.t9 ppolyf_u_1k r_width=3u r_length=23u
X236 VSS.t195 VSS.t193 a_23777_13400# VSS.t194 nfet_03v3 ad=3.05p pd=11.22u as=1.3p ps=5.52u w=5u l=1u
X237 a_7311_24128# a_11839_24980# VSS.t2 ppolyf_u_1k r_width=3u r_length=22u
X238 gilbert_multiplier_current_1.V_x_n voltage_reference_0.v_1_25 I_x2.t0 VSS.t260 nfet_03v3 ad=0.65p pd=3.02u as=1.525p ps=6.22u w=2.5u l=0.5u
X239 VSS.t181 VSS.t179 a_13250_5878# VSS.t180 nfet_03v3 ad=3.05p pd=11.22u as=1.3p ps=5.52u w=5u l=1u
X240 a_14690_5774# a_14558_5878# a_13382_5774# VSS.t23 nfet_03v3 ad=1.3p pd=5.52u as=1.3p ps=5.52u w=5u l=2u
X241 a_3598_8020# voltage_reference_0.v_1_25 a_3619_2602# VSS.t85 nfet_03v3 ad=1.3p pd=5.52u as=1.3p ps=5.52u w=5u l=0.5u
X242 a_22199_13400# voltage_reference_0.v_1_15 voltage_reference_0.v_1_15 VDD.t35 pfet_03v3 ad=2.6p pd=10.52u as=2.6p ps=10.52u w=10u l=1u
X243 a_7657_6436# voltage_reference_0.v_1_25 a_8355_9194# VSS.t60 nfet_03v3 ad=1.3p pd=5.52u as=1.3p ps=5.52u w=5u l=0.5u
X244 a_7311_24128# a_11839_23276# VSS.t1 ppolyf_u_1k r_width=3u r_length=22u
X245 a_13492_1131# tanh_ota_0.V_ref a_13382_5774# VSS.t27 nfet_03v3 ad=1.3p pd=5.52u as=1.3p ps=5.52u w=5u l=2u
X246 tanh_ota_0.V_in_n tanh_ota_0.V_ref a_3415_6100# VSS.t82 nfet_03v3 ad=0.65p pd=3.02u as=0.65p ps=3.02u w=2.5u l=0.5u
X247 a_11555_17360# a_11555_17360# VSS.t303 VSS.t302 nfet_03v3 ad=0.39p pd=2.02u as=0.39p ps=2.02u w=1.5u l=0.5u
X248 a_8559_11644# tanh_ota_0.V_ref tanh_ota_0.V_in_n VSS.t57 nfet_03v3 ad=0.65p pd=3.02u as=0.65p ps=3.02u w=2.5u l=0.5u
X249 tanh_ota_0.V_ref a_13492_1131# VDD.t57 VSS.t314 nfet_03v3 ad=2.6p pd=10.52u as=2.6p ps=10.52u w=10u l=1u
X250 tanh_ota_0.V_in_n V_w2.t15 a_3619_2602# VSS.t8 nfet_03v3 ad=0.65p pd=3.02u as=0.65p ps=3.02u w=2.5u l=0.5u
X251 VSS.t319 a_19458_8812# VSS.t318 ppolyf_u_1k r_width=3u r_length=30u
X252 VSS.t127 VSS.t125 a_7766_18788# VSS.t126 nfet_03v3 ad=3.05p pd=11.22u as=1.3p ps=5.52u w=5u l=0.5u
X253 VDD.t3 a_19458_12220# a_19458_12220# VDD.t2 pfet_03v3 ad=1.3p pd=5.52u as=1.3p ps=5.52u w=5u l=1u
X254 a_8559_11644# V_b.t11 tanh_ota_0.V_in_p VSS.t60 nfet_03v3 ad=0.65p pd=3.02u as=0.65p ps=3.02u w=2.5u l=0.5u
X255 a_8559_11644# V_b.t4 tanh_ota_0.V_in_p VSS.t63 nfet_03v3 ad=0.65p pd=3.02u as=0.65p ps=3.02u w=2.5u l=0.5u
X256 a_3619_2602# V_w2.t1 tanh_ota_0.V_in_n VSS.t81 nfet_03v3 ad=0.65p pd=3.02u as=0.65p ps=3.02u w=2.5u l=0.5u
X257 VDD.t89 VDD.t87 a_14690_5774# VDD.t88 pfet_03v3 ad=6.5p pd=21.3u as=2.6p ps=10.52u w=10u l=2u
X258 a_14690_5774# VSS.t240 VSS.t242 VSS.t241 nfet_03v3 ad=1.3p pd=5.52u as=3.05p ps=11.22u w=5u l=2u
X259 a_3561_18262# a_2717_15824# VSS.t31 ppolyf_u_1k r_width=3u r_length=11.55u
X260 a_8559_11644# tanh_ota_0.V_ref tanh_ota_0.V_in_n VSS.t62 nfet_03v3 ad=0.65p pd=3.02u as=0.65p ps=3.02u w=2.5u l=0.5u
X261 voltage_reference_0.v_1_15 a_23777_13400# VSS.t43 VSS.t42 nfet_03v3 ad=1.3p pd=5.52u as=1.3p ps=5.52u w=5u l=1u
X262 a_3598_19300# tanh_ota_0.V_ref VSS.t55 VSS.t54 nfet_03v3 ad=1.04p pd=4.52u as=1.04p ps=4.52u w=4u l=1u
X263 VDD.t22 a_7766_18788# a_7766_18788# VDD.t21 pfet_03v3 ad=1.3p pd=5.52u as=1.3p ps=5.52u w=5u l=0.5u
X264 VDD.t97 a_14690_5774# a_13492_1131# VDD.t96 pfet_03v3 ad=2.6p pd=10.52u as=2.6p ps=10.52u w=10u l=2u
X265 tanh_ota_0.V_in_n tanh_ota_0.V_ref a_3415_6100# VSS.t8 nfet_03v3 ad=0.65p pd=3.02u as=0.65p ps=3.02u w=2.5u l=0.5u
X266 a_8501_6436# a_7657_3998# VSS.t257 ppolyf_u_1k r_width=3u r_length=11.55u
X267 VSS.t112 VSS.t111 tanh_ota_0.V_in_n VSS.t44 nfet_03v3 ad=1.525p pd=6.22u as=0.65p ps=3.02u w=2.5u l=0.5u
X268 a_14558_20330# a_19854_15770# VSS.t104 ppolyf_u_1k r_width=3u r_length=10u
X269 a_4405_12168# a_3561_9730# VSS.t5 ppolyf_u_1k r_width=3u r_length=11.55u
X270 a_9196_7474# voltage_reference_0.v_1_15 a_8559_11644# VSS.t103 nfet_03v3 ad=1.3p pd=5.52u as=1.3p ps=5.52u w=5u l=0.5u
X271 VDD.t101 a_14690_5774# a_14690_5774# VDD.t100 pfet_03v3 ad=2.6p pd=10.52u as=2.6p ps=10.52u w=10u l=2u
X272 a_19914_7960# a_26642_8812# VSS.t35 ppolyf_u_1k r_width=3u r_length=33u
X273 I_x1.t1 voltage_reference_0.v_1_25 gilbert_multiplier_current_2.V_x_n VSS.t261 nfet_03v3 ad=1.525p pd=6.22u as=0.65p ps=3.02u w=2.5u l=0.5u
X274 tanh_ota_0.V_in_n tanh_ota_0.V_ref a_3415_21020# VSS.t46 nfet_03v3 ad=0.65p pd=3.02u as=0.65p ps=3.02u w=2.5u l=0.5u
X275 V_out_perceptron.t5 a_7766_18788# VDD.t24 VDD.t23 pfet_03v3 ad=1.3p pd=5.52u as=1.3p ps=5.52u w=5u l=0.5u
X276 a_14690_20226# a_14690_20226# VDD.t38 VDD.t37 pfet_03v3 ad=2.6p pd=10.52u as=2.6p ps=10.52u w=10u l=2u
X277 a_3619_2602# tanh_ota_0.V_ref tanh_ota_0.V_in_p VSS.t81 nfet_03v3 ad=0.65p pd=3.02u as=0.65p ps=3.02u w=2.5u l=0.5u
X278 tanh_ota_0.V_in_p V_w1.t5 a_3415_21020# VSS.t46 nfet_03v3 ad=0.65p pd=3.02u as=0.65p ps=3.02u w=2.5u l=0.5u
X279 a_13382_20226# VSS.t164 VSS.t166 VSS.t165 nfet_03v3 ad=0.65p pd=3.02u as=1.525p ps=6.22u w=2.5u l=2u
X280 tanh_ota_0.V_ref a_13492_1131# VDD.t53 VSS.t310 nfet_03v3 ad=2.6p pd=10.52u as=2.6p ps=10.52u w=10u l=1u
X281 VSS.t121 VSS.t120 tanh_ota_0.V_in_n VSS.t63 nfet_03v3 ad=1.525p pd=6.22u as=0.65p ps=3.02u w=2.5u l=0.5u
X282 VSS.t232 VSS.t231 tanh_ota_0.V_in_n VSS.t214 nfet_03v3 ad=1.525p pd=6.22u as=0.65p ps=3.02u w=2.5u l=0.5u
X283 a_11555_17360# a_11555_17360# VSS.t277 VSS.t276 nfet_03v3 ad=0.39p pd=2.02u as=0.39p ps=2.02u w=1.5u l=0.5u
X284 a_11555_17360# a_11555_17360# VSS.t291 VSS.t290 nfet_03v3 ad=0.39p pd=2.02u as=0.39p ps=2.02u w=1.5u l=0.5u
X285 a_13492_24053# a_14690_20226# VDD.t42 VDD.t41 pfet_03v3 ad=2.6p pd=10.52u as=2.6p ps=10.52u w=10u l=2u
X286 gilbert_multiplier_current_2.V_x_n voltage_reference_0.v_1_25 VSS.t6 ppolyf_u_1k r_width=3u r_length=8.1u
X287 a_3415_6100# V_w2.t5 tanh_ota_0.V_in_p VSS.t81 nfet_03v3 ad=0.65p pd=3.02u as=0.65p ps=3.02u w=2.5u l=0.5u
X288 a_9196_7474# tanh_ota_0.V_ref VSS.t78 VSS.t77 nfet_03v3 ad=1.04p pd=4.52u as=1.04p ps=4.52u w=4u l=1u
X289 VDD.t31 a_13492_24053# voltage_reference_0.v_1_25 VSS.t97 nfet_03v3 ad=2.6p pd=10.52u as=2.6p ps=10.52u w=10u l=1u
X290 a_10295_19296# tanh_ota_0.V_in_p a_7766_18788# VSS.t108 nfet_03v3 ad=1.3p pd=5.52u as=1.3p ps=5.52u w=5u l=0.5u
X291 a_2717_12168# a_3561_9730# VSS.t31 ppolyf_u_1k r_width=3u r_length=11.55u
X292 VSS.t68 tanh_ota_0.V_ref a_3598_8020# VSS.t67 nfet_03v3 ad=1.04p pd=4.52u as=1.04p ps=4.52u w=4u l=1u
X293 V_out_perceptron.t4 a_7766_18788# VDD.t14 VDD.t13 pfet_03v3 ad=1.3p pd=5.52u as=1.3p ps=5.52u w=5u l=0.5u
X294 a_14690_20226# VSS.t175 VSS.t176 VSS.t165 nfet_03v3 ad=1.3p pd=5.52u as=3.05p ps=11.22u w=5u l=2u
X295 gilbert_multiplier_current_1.V_x_n voltage_reference_0.v_1_25 VSS.t6 ppolyf_u_1k r_width=3u r_length=8.1u
X296 a_8559_11644# V_b.t6 tanh_ota_0.V_in_p VSS.t57 nfet_03v3 ad=0.65p pd=3.02u as=0.65p ps=3.02u w=2.5u l=0.5u
X297 VDD.t84 VDD.t83 a_23777_13400# VDD.t35 pfet_03v3 ad=6.5p pd=21.3u as=2.6p ps=10.52u w=10u l=1u
X298 a_9805_17650# a_8953_14522# VSS.t87 ppolyf_u_1k r_width=3u r_length=15u
X299 a_13330_16152# a_19458_17004# VSS.t265 ppolyf_u_1k r_width=3u r_length=30u
X300 a_8559_11644# tanh_ota_0.V_ref tanh_ota_0.V_in_n VSS.t60 nfet_03v3 ad=0.65p pd=3.02u as=0.65p ps=3.02u w=2.5u l=0.5u
X301 a_8355_9194# V_b.t0 tanh_ota_0.V_in_n VSS.t64 nfet_03v3 ad=0.65p pd=3.02u as=0.65p ps=3.02u w=2.5u l=0.5u
X302 a_23777_13400# VSS.t182 VSS.t184 VSS.t183 nfet_03v3 ad=1.3p pd=5.52u as=3.05p ps=11.22u w=5u l=1u
X303 VSS.t223 VSS.t222 a_3415_6100# VSS.t83 nfet_03v3 ad=3.05p pd=11.22u as=1.3p ps=5.52u w=5u l=0.5u
X304 a_8355_9194# tanh_ota_0.V_ref tanh_ota_0.V_in_p VSS.t62 nfet_03v3 ad=0.65p pd=3.02u as=0.65p ps=3.02u w=2.5u l=0.5u
X305 VSS.t132 VSS.t131 a_3619_22696# VSS.t88 nfet_03v3 ad=3.05p pd=11.22u as=1.3p ps=5.52u w=5u l=0.5u
X306 VDD.t59 VSS.t254 VSS.t256 VSS.t255 nfet_03v3 ad=2.6p pd=10.52u as=6.1p ps=21.22u w=10u l=1u
X307 a_3619_22696# tanh_ota_0.V_ref tanh_ota_0.V_in_p VSS.t44 nfet_03v3 ad=0.65p pd=3.02u as=0.65p ps=3.02u w=2.5u l=0.5u
X308 VSS.t142 VSS.t141 tanh_ota_0.V_in_p VSS.t47 nfet_03v3 ad=1.525p pd=6.22u as=0.65p ps=3.02u w=2.5u l=0.5u
X309 a_3619_22696# V_w1.t13 tanh_ota_0.V_in_n VSS.t44 nfet_03v3 ad=0.65p pd=3.02u as=0.65p ps=3.02u w=2.5u l=0.5u
X310 VSS.t145 VSS.t143 VDD.t58 VSS.t144 nfet_03v3 ad=6.1p pd=21.22u as=2.6p ps=10.52u w=10u l=1u
X311 VSS.t169 VSS.t167 VSS.t169 VSS.t168 nfet_03v3 ad=0.915p pd=4.22u as=0 ps=0 w=1.5u l=0.5u
X312 a_14558_20330# a_19467_13334# VSS.t262 ppolyf_u_1k r_width=3u r_length=20u
X313 VSS.t136 VSS.t135 tanh_ota_0.V_in_p VSS.t45 nfet_03v3 ad=1.525p pd=6.22u as=0.65p ps=3.02u w=2.5u l=0.5u
X314 a_3598_19300# VSS.t155 VSS.t157 VSS.t156 nfet_03v3 ad=1.04p pd=4.52u as=2.44p ps=9.22u w=4u l=1u
X315 a_3619_2602# V_w2.t3 tanh_ota_0.V_in_n VSS.t7 nfet_03v3 ad=0.65p pd=3.02u as=0.65p ps=3.02u w=2.5u l=0.5u
X316 voltage_reference_0.v_1_15 voltage_reference_0.v_1_15 a_22199_13400# VDD.t35 pfet_03v3 ad=2.6p pd=10.52u as=2.6p ps=10.52u w=10u l=1u
X317 a_14690_5774# a_14690_5774# VDD.t95 VDD.t94 pfet_03v3 ad=2.6p pd=10.52u as=2.6p ps=10.52u w=10u l=2u
X318 tanh_ota_0.V_in_p V_w2.t11 a_3415_6100# VSS.t8 nfet_03v3 ad=0.65p pd=3.02u as=0.65p ps=3.02u w=2.5u l=0.5u
X319 VSS.t228 VSS.t227 a_7657_6436# VSS.t75 nfet_03v3 ad=2.44p pd=9.22u as=1.04p ps=4.52u w=4u l=1u
X320 VSS.t282 a_11555_17360# a_10295_19296# VSS.t3 nfet_03v3 ad=0.39p pd=2.02u as=0.39p ps=2.02u w=1.5u l=0.5u
X321 a_9196_7474# a_9345_3998# VSS.t317 ppolyf_u_1k r_width=3u r_length=11.55u
X322 VDD.t78 VDD.t76 a_19458_12220# VDD.t77 pfet_03v3 ad=3.25p pd=11.3u as=1.3p ps=5.52u w=5u l=1u
X323 a_4405_12168# a_3598_8020# VSS.t101 ppolyf_u_1k r_width=3u r_length=11.55u
X324 a_13492_1131# a_14690_5774# VDD.t99 VDD.t98 pfet_03v3 ad=2.6p pd=10.52u as=2.6p ps=10.52u w=10u l=2u
X325 a_8501_6436# a_9345_3998# VSS.t317 ppolyf_u_1k r_width=3u r_length=11.55u
X326 a_3619_2602# VSS.t216 VSS.t217 VSS.t84 nfet_03v3 ad=1.3p pd=5.52u as=3.05p ps=11.22u w=5u l=0.5u
X327 a_2717_18262# tanh_ota_0.V_ref VSS.t51 VSS.t50 nfet_03v3 ad=1.04p pd=4.52u as=1.04p ps=4.52u w=4u l=1u
X328 VSS.t192 VSS.t191 tanh_ota_0.V_in_p VSS.t64 nfet_03v3 ad=1.525p pd=6.22u as=0.65p ps=3.02u w=2.5u l=0.5u
X329 a_23777_13400# a_23777_13400# VSS.t37 VSS.t36 nfet_03v3 ad=1.3p pd=5.52u as=1.3p ps=5.52u w=5u l=1u
X330 a_13330_9664# a_19458_10516# VSS.t89 ppolyf_u_1k r_width=3u r_length=30u
X331 VSS.t70 tanh_ota_0.V_ref a_2717_9730# VSS.t69 nfet_03v3 ad=1.04p pd=4.52u as=1.04p ps=4.52u w=4u l=1u
X332 VSS.t197 VSS.t196 a_8355_9194# VSS.t57 nfet_03v3 ad=3.05p pd=11.22u as=1.3p ps=5.52u w=5u l=0.5u
X333 a_14690_5774# VDD.t90 VDD.t92 VDD.t91 pfet_03v3 ad=2.6p pd=10.52u as=6.5p ps=21.3u w=10u l=2u
X334 tanh_ota_0.V_ref a_13492_1131# VDD.t51 VSS.t308 nfet_03v3 ad=2.6p pd=10.52u as=2.6p ps=10.52u w=10u l=1u
X335 a_3619_2602# tanh_ota_0.V_ref tanh_ota_0.V_in_p VSS.t85 nfet_03v3 ad=0.65p pd=3.02u as=0.65p ps=3.02u w=2.5u l=0.5u
X336 VDD.t8 a_19458_12220# a_22199_13400# VDD.t4 pfet_03v3 ad=1.3p pd=5.52u as=1.3p ps=5.52u w=5u l=1u
X337 tanh_ota_0.V_ref VSS.t316 VSS.t315 ppolyf_u_1k r_width=3u r_length=20u
X338 a_3619_2602# tanh_ota_0.V_ref tanh_ota_0.V_in_p VSS.t7 nfet_03v3 ad=0.65p pd=3.02u as=0.65p ps=3.02u w=2.5u l=0.5u
X339 V_shift.t0 tanh_ota_0.V_in_p VSS.t33 ppolyf_u_1k r_width=3u r_length=7.3u
X340 tanh_ota_0.V_in_p V_b.t10 a_8559_11644# VSS.t61 nfet_03v3 ad=0.65p pd=3.02u as=0.65p ps=3.02u w=2.5u l=0.5u
R0 V_w2.n3 V_w2.t4 42.2608
R1 V_w2.n11 V_w2.t7 42.2608
R2 V_w2.n4 V_w2.t0 42.2585
R3 V_w2.n12 V_w2.t3 42.2585
R4 V_w2.n0 V_w2.t13 33.4977
R5 V_w2.n1 V_w2.t9 33.4977
R6 V_w2.n5 V_w2.t5 33.4977
R7 V_w2.n6 V_w2.t1 33.4977
R8 V_w2.n8 V_w2.t14 33.4977
R9 V_w2.n9 V_w2.t10 33.4977
R10 V_w2.n0 V_w2.t12 33.2585
R11 V_w2.n1 V_w2.t8 33.2585
R12 V_w2.n5 V_w2.t6 33.2585
R13 V_w2.n6 V_w2.t2 33.2585
R14 V_w2.n8 V_w2.t15 33.2585
R15 V_w2.n9 V_w2.t11 33.2585
R16 V_w2.n7 V_w2.n5 9.8735
R17 V_w2.n2 V_w2.n0 9.87125
R18 V_w2.n10 V_w2.n8 9.87125
R19 V_w2.n2 V_w2.n1 9.0005
R20 V_w2.n7 V_w2.n6 9.0005
R21 V_w2.n10 V_w2.n9 9.0005
R22 V_w2.n13 V_w2 5.44035
R23 V_w2.n3 V_w2.n2 1.787
R24 V_w2.n11 V_w2.n10 1.787
R25 V_w2 V_w2.n4 1.11537
R26 V_w2.n4 V_w2.n3 0.8735
R27 V_w2.n12 V_w2.n11 0.8735
R28 V_w2.n14 V_w2.n13 0.689
R29 V_w2.n14 V_w2.n7 0.2615
R30 V_w2.n13 V_w2.n12 0.2615
R31 V_w2 V_w2.n14 0.064625
R32 V_b.n12 V_b.t11 42.2608
R33 V_b.n6 V_b.t8 42.2608
R34 V_b.n13 V_b.t15 42.2585
R35 V_b.n7 V_b.t12 42.2585
R36 V_b.n10 V_b.t6 33.4977
R37 V_b.n9 V_b.t2 33.4977
R38 V_b.n1 V_b.t14 33.4977
R39 V_b.n0 V_b.t10 33.4977
R40 V_b.n4 V_b.t5 33.4977
R41 V_b.n3 V_b.t1 33.4977
R42 V_b.n10 V_b.t7 33.2585
R43 V_b.n9 V_b.t3 33.2585
R44 V_b.n1 V_b.t13 33.2585
R45 V_b.n0 V_b.t9 33.2585
R46 V_b.n4 V_b.t4 33.2585
R47 V_b.n3 V_b.t0 33.2585
R48 V_b.n14 V_b 10.9979
R49 V_b.n2 V_b.n0 9.8735
R50 V_b.n11 V_b.n9 9.87125
R51 V_b.n5 V_b.n3 9.87125
R52 V_b.n11 V_b.n10 9.0005
R53 V_b.n2 V_b.n1 9.0005
R54 V_b.n5 V_b.n4 9.0005
R55 V_b.n12 V_b.n11 1.787
R56 V_b.n6 V_b.n5 1.787
R57 V_b.n8 V_b.n7 0.95
R58 V_b.n13 V_b.n12 0.8735
R59 V_b.n7 V_b.n6 0.8735
R60 V_b V_b.n14 0.854375
R61 V_b.n14 V_b.n13 0.2615
R62 V_b.n8 V_b.n2 0.2615
R63 V_b V_b.n8 0.064625
R64 I_x2.n0 I_x2.t1 5.11115
R65 I_x2.n0 I_x2.t0 4.90644
R66 I_x2 I_x2.n0 2.43698
R67 I_x1.n0 I_x1.t1 5.11215
R68 I_x1.n0 I_x1.t0 4.90744
R69 I_x1 I_x1.n0 2.43698
R70 V_out_perceptron.n5 V_out_perceptron 21.7985
R71 V_out_perceptron.n4 V_out_perceptron.n0 11.208
R72 V_out_perceptron.n4 V_out_perceptron.n3 6.98133
R73 V_out_perceptron.n6 V_out_perceptron.n4 6.9036
R74 V_out_perceptron.n3 V_out_perceptron.n2 3.19085
R75 V_out_perceptron.n3 V_out_perceptron.n1 3.19026
R76 V_out_perceptron.n5 V_out_perceptron.t6 2.71983
R77 V_out_perceptron.n6 V_out_perceptron.n5 1.45467
R78 V_out_perceptron.n1 V_out_perceptron.t3 0.3645
R79 V_out_perceptron.n1 V_out_perceptron.t5 0.3645
R80 V_out_perceptron.n2 V_out_perceptron.t2 0.3645
R81 V_out_perceptron.n2 V_out_perceptron.t4 0.3645
R82 V_out_perceptron.n0 V_out_perceptron.t0 0.3281
R83 V_out_perceptron.n0 V_out_perceptron.t1 0.3281
R84 V_out_perceptron V_out_perceptron.n6 0.270008
R85 V_shift V_shift.t0 12.5976
R86 V_w1.n12 V_w1.t11 42.2608
R87 V_w1.n3 V_w1.t8 42.2608
R88 V_w1.n13 V_w1.t15 42.2585
R89 V_w1.n4 V_w1.t12 42.2585
R90 V_w1.n10 V_w1.t6 33.4977
R91 V_w1.n9 V_w1.t2 33.4977
R92 V_w1.n7 V_w1.t13 33.4977
R93 V_w1.n6 V_w1.t9 33.4977
R94 V_w1.n1 V_w1.t5 33.4977
R95 V_w1.n0 V_w1.t1 33.4977
R96 V_w1.n10 V_w1.t7 33.2585
R97 V_w1.n9 V_w1.t3 33.2585
R98 V_w1.n7 V_w1.t14 33.2585
R99 V_w1.n6 V_w1.t10 33.2585
R100 V_w1.n1 V_w1.t4 33.2585
R101 V_w1.n0 V_w1.t0 33.2585
R102 V_w1.n8 V_w1.n6 9.8735
R103 V_w1.n11 V_w1.n9 9.87125
R104 V_w1.n2 V_w1.n0 9.87125
R105 V_w1.n11 V_w1.n10 9.0005
R106 V_w1.n8 V_w1.n7 9.0005
R107 V_w1.n2 V_w1.n1 9.0005
R108 V_w1.n5 V_w1 4.61799
R109 V_w1.n12 V_w1.n11 1.787
R110 V_w1.n3 V_w1.n2 1.787
R111 V_w1.n5 V_w1.n4 1.06475
R112 V_w1.n14 V_w1.n13 0.95
R113 V_w1.n13 V_w1.n12 0.8735
R114 V_w1.n4 V_w1.n3 0.8735
R115 V_w1.n14 V_w1.n8 0.2615
R116 V_w1 V_w1.n14 0.064625
R117 V_w1 V_w1.n5 0.051125
R118 VDD.n126 VDD.n106 489.601
R119 VDD.t35 VDD.n114 464.3
R120 VDD.t4 VDD.n137 264
R121 VDD.n188 VDD.n4 244.458
R122 VDD.n88 VDD.n12 244.458
R123 VDD.n190 VDD.n4 239.732
R124 VDD.n90 VDD.n12 239.732
R125 VDD.n188 VDD.n5 239.649
R126 VDD.n88 VDD.n11 239.649
R127 VDD.n190 VDD.n5 234.924
R128 VDD.n90 VDD.n11 234.924
R129 VDD.t77 VDD.n151 221.399
R130 VDD.n153 VDD.t62 221.399
R131 VDD.n127 VDD.n114 195.714
R132 VDD.n125 VDD.n114 192.067
R133 VDD.t94 VDD.t88 189.261
R134 VDD.t96 VDD.t94 189.261
R135 VDD.t98 VDD.t100 189.261
R136 VDD.t100 VDD.t91 189.261
R137 VDD.t37 VDD.t71 189.261
R138 VDD.t39 VDD.t37 189.261
R139 VDD.t41 VDD.t43 189.261
R140 VDD.t43 VDD.t74 189.261
R141 VDD.t0 VDD.t77 184.466
R142 VDD.t62 VDD.t2 184.466
R143 VDD.t88 VDD.n4 174.513
R144 VDD.t91 VDD.n5 174.513
R145 VDD.t71 VDD.n11 174.513
R146 VDD.t74 VDD.n12 174.513
R147 VDD.n64 VDD.n50 170.68
R148 VDD.n66 VDD.n50 170.68
R149 VDD.n64 VDD.n51 168.359
R150 VDD.t65 VDD.n50 163.623
R151 VDD.t68 VDD.n51 163.623
R152 VDD.n66 VDD.n51 163.387
R153 VDD.n140 VDD.n104 147.885
R154 VDD.n151 VDD.n99 122.684
R155 VDD.n151 VDD.n100 122.684
R156 VDD.n153 VDD.n99 122.684
R157 VDD.n153 VDD.n100 122.684
R158 VDD.t9 VDD.t65 106.029
R159 VDD.t11 VDD.t9 106.029
R160 VDD.t13 VDD.t11 106.029
R161 VDD.t15 VDD.t13 106.029
R162 VDD.t17 VDD.t19 106.029
R163 VDD.t19 VDD.t23 106.029
R164 VDD.t23 VDD.t21 106.029
R165 VDD.t21 VDD.t68 106.029
R166 VDD.n189 VDD.t96 105.52
R167 VDD.n89 VDD.t41 105.52
R168 VDD.n125 VDD.n116 101.463
R169 VDD.n128 VDD.n127 101.463
R170 VDD.n140 VDD.n139 96.5954
R171 VDD.n152 VDD.t0 92.2335
R172 VDD.t2 VDD.n152 92.2335
R173 VDD.n189 VDD.t98 83.7406
R174 VDD.n89 VDD.t39 83.7406
R175 VDD.n136 VDD.n107 82.34
R176 VDD.n136 VDD.n108 82.34
R177 VDD.n65 VDD.t15 68.0878
R178 VDD.n108 VDD.n105 53.8821
R179 VDD.n107 VDD.n104 53.8821
R180 VDD.n55 VDD.t67 51.7769
R181 VDD.n54 VDD.t64 51.7769
R182 VDD.n112 VDD.t85 48.2504
R183 VDD.n119 VDD.t83 48.2504
R184 VDD.n137 VDD.n106 40.8005
R185 VDD.n65 VDD.t17 37.9423
R186 VDD.n126 VDD.t35 36.8005
R187 VDD.n101 VDD.t79 30.0004
R188 VDD.n130 VDD.t81 30.0004
R189 VDD.n144 VDD.t76 30.0004
R190 VDD.n97 VDD.t61 30.0004
R191 VDD.n0 VDD.t87 22.997
R192 VDD.n2 VDD.t90 22.997
R193 VDD.n8 VDD.t73 22.997
R194 VDD.n9 VDD.t70 22.997
R195 VDD.n138 VDD.t4 15.2005
R196 VDD.n55 VDD.n54 11.066
R197 VDD.n117 VDD.t93 9.10983
R198 VDD.n182 VDD.n160 7.88616
R199 VDD.n35 VDD.n13 7.88616
R200 VDD.n182 VDD.n181 6.44616
R201 VDD.n35 VDD.n34 6.44616
R202 VDD.n164 VDD.n161 6.30761
R203 VDD.n170 VDD.n169 6.30761
R204 VDD.n19 VDD.n18 6.30761
R205 VDD.n33 VDD.n16 6.30761
R206 VDD.n167 VDD.n164 6.30642
R207 VDD.n173 VDD.n169 6.30642
R208 VDD.n22 VDD.n18 6.30642
R209 VDD.n30 VDD.n16 6.30642
R210 VDD.n122 VDD.n116 6.3005
R211 VDD.n116 VDD.n106 6.3005
R212 VDD.n129 VDD.n128 6.3005
R213 VDD.n128 VDD.n106 6.3005
R214 VDD.n77 VDD.n76 6.21365
R215 VDD.n180 VDD.n179 5.58761
R216 VDD.n175 VDD.n162 5.58761
R217 VDD.n172 VDD.n170 5.58761
R218 VDD.n166 VDD.n161 5.58761
R219 VDD.n25 VDD.n23 5.58761
R220 VDD.n28 VDD.n14 5.58761
R221 VDD.n33 VDD.n32 5.58761
R222 VDD.n21 VDD.n19 5.58761
R223 VDD.n179 VDD.n177 5.58642
R224 VDD.n176 VDD.n175 5.58642
R225 VDD.n173 VDD.n172 5.58642
R226 VDD.n167 VDD.n166 5.58642
R227 VDD.n26 VDD.n25 5.58642
R228 VDD.n29 VDD.n28 5.58642
R229 VDD.n32 VDD.n30 5.58642
R230 VDD.n22 VDD.n21 5.58642
R231 VDD.n116 VDD.n107 5.30576
R232 VDD.n128 VDD.n108 5.30576
R233 VDD.n157 VDD.n156 5.23945
R234 VDD.n94 VDD.n93 5.23945
R235 VDD.n73 VDD.n72 4.90112
R236 VDD.n75 VDD.n74 4.5005
R237 VDD.n42 VDD.n41 4.5005
R238 VDD.n78 VDD.n37 4.5005
R239 VDD.n79 VDD.n78 4.5005
R240 VDD.n93 VDD.t36 4.32562
R241 VDD.n159 VDD.n158 2.81655
R242 VDD.n86 VDD.n7 2.81655
R243 VDD.n124 VDD.n118 2.74432
R244 VDD.n73 VDD.t47 2.71983
R245 VDD.n72 VDD.t45 2.71983
R246 VDD.n186 VDD.n184 2.32037
R247 VDD.n84 VDD.n82 2.32037
R248 VDD.n40 VDD.n38 2.29636
R249 VDD.n156 VDD.n94 2.28366
R250 VDD.n77 VDD.n36 2.26477
R251 VDD.n76 VDD.n75 2.2505
R252 VDD.n74 VDD.n43 2.23838
R253 VDD.n41 VDD.n39 2.23803
R254 VDD.n184 VDD.n182 2.02787
R255 VDD.n82 VDD.n35 2.02787
R256 VDD.n101 VDD.t80 1.87444
R257 VDD.n130 VDD.t82 1.87444
R258 VDD.n0 VDD.t89 1.85476
R259 VDD.n2 VDD.t92 1.85476
R260 VDD.n8 VDD.t75 1.85476
R261 VDD.n9 VDD.t72 1.85476
R262 VDD.n112 VDD.t86 1.85358
R263 VDD.n119 VDD.t84 1.85358
R264 VDD.n37 VDD 1.82246
R265 VDD.n92 VDD.n91 1.81826
R266 VDD VDD.n1 1.78392
R267 VDD.n63 VDD.n52 1.778
R268 VDD.n191 VDD.n3 1.74958
R269 VDD.n91 VDD.n10 1.74958
R270 VDD.n63 VDD.n62 1.70932
R271 VDD.n186 VDD.n185 1.63418
R272 VDD.n159 VDD.n6 1.63418
R273 VDD.n84 VDD.n83 1.63418
R274 VDD.n86 VDD.n85 1.63418
R275 VDD.n156 VDD.n155 1.58497
R276 VDD.n149 VDD.n94 1.58497
R277 VDD.n183 VDD.n3 1.51747
R278 VDD.n117 VDD.n115 1.48432
R279 VDD.n80 VDD.n79 1.44455
R280 VDD.n158 VDD.n157 1.39432
R281 VDD.n93 VDD.n7 1.39432
R282 VDD.n147 VDD.n146 1.35986
R283 VDD.n110 VDD.n109 1.35867
R284 VDD.n134 VDD.n111 1.35867
R285 VDD.n69 VDD.n46 1.31486
R286 VDD.n68 VDD.n47 1.31486
R287 VDD.n49 VDD.n48 1.31486
R288 VDD.n59 VDD.n58 1.31486
R289 VDD.n118 VDD.n117 1.31261
R290 VDD.n81 VDD.n80 1.20247
R291 VDD.n124 VDD.n123 1.19063
R292 VDD.n115 VDD.n113 1.19063
R293 VDD.n45 VDD.t66 1.16628
R294 VDD.n57 VDD.t69 1.16628
R295 VDD.n145 VDD.t78 1.16628
R296 VDD.n96 VDD.t63 1.16628
R297 VDD.n71 VDD.n44 0.9455
R298 VDD.n61 VDD.n60 0.932105
R299 VDD.n121 VDD.n110 0.881553
R300 VDD.n134 VDD.n133 0.881553
R301 VDD.n53 VDD.n45 0.86971
R302 VDD.n57 VDD.n56 0.86971
R303 VDD.n76 VDD.n38 0.8477
R304 VDD.n155 VDD.n154 0.827079
R305 VDD.n150 VDD.n149 0.827079
R306 VDD.n121 VDD.n120 0.825895
R307 VDD.n133 VDD.n132 0.825895
R308 VDD.n148 VDD.n145 0.782079
R309 VDD.n96 VDD.n95 0.782079
R310 VDD.n70 VDD.n45 0.737079
R311 VDD.n60 VDD.n57 0.737079
R312 VDD.n177 VDD.n167 0.7205
R313 VDD.n177 VDD.n176 0.7205
R314 VDD.n176 VDD.n173 0.7205
R315 VDD.n180 VDD.n162 0.7205
R316 VDD.n26 VDD.n22 0.7205
R317 VDD.n29 VDD.n26 0.7205
R318 VDD.n30 VDD.n29 0.7205
R319 VDD.n23 VDD.n14 0.7205
R320 VDD.n145 VDD.n144 0.708658
R321 VDD.n97 VDD.n96 0.708658
R322 VDD.n62 VDD.n61 0.696816
R323 VDD.n148 VDD.n147 0.668395
R324 VDD.n147 VDD.n95 0.668395
R325 VDD.n72 VDD.n71 0.668055
R326 VDD.n120 VDD.n102 0.663658
R327 VDD.n132 VDD.n131 0.663658
R328 VDD.n154 VDD.n98 0.663658
R329 VDD.n150 VDD.n143 0.663658
R330 VDD.n52 VDD.n44 0.661289
R331 VDD.n187 VDD.n159 0.586684
R332 VDD.n87 VDD.n86 0.586684
R333 VDD.n120 VDD.n104 0.5255
R334 VDD.n138 VDD.n104 0.5255
R335 VDD.n132 VDD.n105 0.5255
R336 VDD.n154 VDD.n153 0.5255
R337 VDD.n151 VDD.n150 0.5255
R338 VDD.n142 VDD.n102 0.525105
R339 VDD.n131 VDD.n103 0.525105
R340 VDD.n187 VDD.n186 0.518
R341 VDD.n87 VDD.n84 0.518
R342 VDD.n184 VDD.n183 0.496684
R343 VDD.n82 VDD.n81 0.496684
R344 VDD.n170 VDD.n160 0.4955
R345 VDD.n181 VDD.n180 0.4955
R346 VDD.n19 VDD.n13 0.4955
R347 VDD.n34 VDD.n14 0.4955
R348 VDD.n50 VDD.n44 0.4205
R349 VDD.n61 VDD.n51 0.4205
R350 VDD.n147 VDD.n100 0.4205
R351 VDD.n152 VDD.n100 0.4205
R352 VDD.n141 VDD.n99 0.4205
R353 VDD.n152 VDD.n99 0.4205
R354 VDD.n46 VDD.t10 0.3645
R355 VDD.n46 VDD.t12 0.3645
R356 VDD.n47 VDD.t14 0.3645
R357 VDD.n47 VDD.t16 0.3645
R358 VDD.n48 VDD.t18 0.3645
R359 VDD.n48 VDD.t20 0.3645
R360 VDD.n58 VDD.t24 0.3645
R361 VDD.n58 VDD.t22 0.3645
R362 VDD.n109 VDD.t5 0.3645
R363 VDD.n109 VDD.t6 0.3645
R364 VDD.n111 VDD.t7 0.3645
R365 VDD.n111 VDD.t8 0.3645
R366 VDD.n146 VDD.t1 0.3645
R367 VDD.n146 VDD.t3 0.3645
R368 VDD.n139 VDD.n138 0.343917
R369 VDD.n135 VDD.n110 0.3155
R370 VDD.n135 VDD.n134 0.3155
R371 VDD.n164 VDD.n163 0.3155
R372 VDD.n179 VDD.n178 0.3155
R373 VDD.n175 VDD.n174 0.3155
R374 VDD.n172 VDD.n171 0.3155
R375 VDD.n169 VDD.n168 0.3155
R376 VDD.n166 VDD.n165 0.3155
R377 VDD.n18 VDD.n17 0.3155
R378 VDD.n25 VDD.n24 0.3155
R379 VDD.n28 VDD.n27 0.3155
R380 VDD.n32 VDD.n31 0.3155
R381 VDD.n16 VDD.n15 0.3155
R382 VDD.n21 VDD.n20 0.3155
R383 VDD.n118 VDD.n114 0.3005
R384 VDD.n136 VDD.n135 0.3005
R385 VDD.n137 VDD.n136 0.3005
R386 VDD.n141 VDD.n140 0.3005
R387 VDD.n125 VDD.n124 0.274413
R388 VDD.n126 VDD.n125 0.274413
R389 VDD.n127 VDD.n115 0.274413
R390 VDD.n127 VDD.n126 0.274413
R391 VDD.n183 VDD.n5 0.274413
R392 VDD.n158 VDD.n4 0.274413
R393 VDD.n81 VDD.n11 0.274413
R394 VDD.n12 VDD.n7 0.274413
R395 VDD.n64 VDD.n63 0.263
R396 VDD.n65 VDD.n64 0.263
R397 VDD.n67 VDD.n66 0.263
R398 VDD.n66 VDD.n65 0.263
R399 VDD.n123 VDD.n122 0.259842
R400 VDD.n129 VDD.n113 0.259842
R401 VDD.n191 VDD.n190 0.185794
R402 VDD.n190 VDD.n189 0.185794
R403 VDD.n188 VDD.n187 0.185794
R404 VDD.n189 VDD.n188 0.185794
R405 VDD.n88 VDD.n87 0.185794
R406 VDD.n89 VDD.n88 0.185794
R407 VDD.n91 VDD.n90 0.185794
R408 VDD.n90 VDD.n89 0.185794
R409 VDD.n185 VDD.t99 0.1825
R410 VDD.n185 VDD.t101 0.1825
R411 VDD.n6 VDD.t95 0.1825
R412 VDD.n6 VDD.t97 0.1825
R413 VDD.n83 VDD.t38 0.1825
R414 VDD.n83 VDD.t40 0.1825
R415 VDD.n85 VDD.t42 0.1825
R416 VDD.n85 VDD.t44 0.1825
R417 VDD.n139 VDD.n105 0.182439
R418 VDD.n1 VDD.n0 0.181684
R419 VDD.n3 VDD.n2 0.181684
R420 VDD.n92 VDD.n8 0.181684
R421 VDD.n10 VDD.n9 0.181684
R422 VDD.n165 VDD.t49 0.1643
R423 VDD.n165 VDD.t50 0.1643
R424 VDD.n163 VDD.t60 0.1643
R425 VDD.n163 VDD.t48 0.1643
R426 VDD.n178 VDD.t51 0.1643
R427 VDD.n178 VDD.t52 0.1643
R428 VDD.n174 VDD.t53 0.1643
R429 VDD.n174 VDD.t54 0.1643
R430 VDD.n168 VDD.t57 0.1643
R431 VDD.n168 VDD.t59 0.1643
R432 VDD.n171 VDD.t55 0.1643
R433 VDD.n171 VDD.t56 0.1643
R434 VDD.n20 VDD.t26 0.1643
R435 VDD.n20 VDD.t27 0.1643
R436 VDD.n17 VDD.t58 0.1643
R437 VDD.n17 VDD.t25 0.1643
R438 VDD.n24 VDD.t28 0.1643
R439 VDD.n24 VDD.t29 0.1643
R440 VDD.n27 VDD.t30 0.1643
R441 VDD.n27 VDD.t31 0.1643
R442 VDD.n31 VDD.t32 0.1643
R443 VDD.n31 VDD.t33 0.1643
R444 VDD.n15 VDD.t34 0.1643
R445 VDD.n15 VDD.t46 0.1643
R446 VDD.n103 VDD.n98 0.163921
R447 VDD.n143 VDD.n142 0.163921
R448 VDD.n80 VDD.n10 0.140758
R449 VDD.n181 VDD.n161 0.1355
R450 VDD.n162 VDD.n160 0.1355
R451 VDD.n23 VDD.n13 0.1355
R452 VDD.n34 VDD.n33 0.1355
R453 VDD.n53 VDD.n52 0.123658
R454 VDD.n62 VDD.n56 0.123658
R455 VDD.n113 VDD.n112 0.123658
R456 VDD.n102 VDD.n101 0.123658
R457 VDD.n123 VDD.n119 0.123658
R458 VDD.n131 VDD.n130 0.123658
R459 VDD.n157 VDD.n1 0.123658
R460 VDD.n149 VDD.n148 0.123658
R461 VDD.n144 VDD.n143 0.123658
R462 VDD.n98 VDD.n97 0.123658
R463 VDD.n155 VDD.n95 0.123658
R464 VDD.n93 VDD.n92 0.123658
R465 VDD.n122 VDD.n121 0.122474
R466 VDD.n133 VDD.n129 0.122474
R467 VDD.n142 VDD.n141 0.101043
R468 VDD.n141 VDD.n103 0.101043
R469 VDD.n54 VDD.n53 0.0549737
R470 VDD.n56 VDD.n55 0.0549737
R471 VDD.n70 VDD.n69 0.0545984
R472 VDD.n60 VDD.n59 0.0545984
R473 VDD.n43 VDD.n39 0.0526701
R474 VDD.n69 VDD.n68 0.0506639
R475 VDD.n59 VDD.n49 0.0506639
R476 VDD VDD.n191 0.0348421
R477 VDD.n75 VDD.n39 0.02694
R478 VDD.n78 VDD.n77 0.0263511
R479 VDD.n43 VDD.n42 0.0262301
R480 VDD.n68 VDD 0.025582
R481 VDD.n79 VDD.n36 0.0251695
R482 VDD.n37 VDD.n36 0.0251695
R483 VDD.n71 VDD.n70 0.0226311
R484 VDD.n67 VDD.n49 0.0220164
R485 VDD.n74 VDD.n73 0.0194588
R486 VDD.n74 VDD.n40 0.0127369
R487 VDD.n41 VDD.n40 0.0127369
R488 VDD VDD.n67 0.00406557
R489 VDD.n42 VDD.n38 0.000978723
R490 VSS.t35 VSS.n166 19746.5
R491 VSS.n396 VSS.t102 14824.4
R492 VSS.n413 VSS.t318 14157.8
R493 VSS.n398 VSS.n397 7247.77
R494 VSS.n415 VSS.n413 6135.2
R495 VSS.n396 VSS.n395 6135.2
R496 VSS.n413 VSS.t35 3660.6
R497 VSS.n398 VSS.n396 3317.54
R498 VSS.n415 VSS.n414 2761.47
R499 VSS.n395 VSS.n249 2516.16
R500 VSS.t104 VSS.n166 2106.63
R501 VSS.t262 VSS.t86 993.824
R502 VSS.t304 VSS.t90 993.824
R503 VSS.t35 VSS.n412 931.111
R504 VSS.t105 VSS.t102 760.088
R505 VSS.t105 VSS.t265 760.088
R506 VSS.t86 VSS.t10 760.088
R507 VSS.t320 VSS.t318 760.088
R508 VSS.n401 VSS.t194 687.872
R509 VSS.n411 VSS.t183 687.872
R510 VSS.n397 VSS.t10 686.043
R511 VSS.t106 VSS.n167 686.043
R512 VSS.n399 VSS.t9 648.634
R513 VSS.t9 VSS.n398 634.202
R514 VSS.t194 VSS.t36 587.396
R515 VSS.t36 VSS.t38 587.396
R516 VSS.t42 VSS.t40 587.396
R517 VSS.t40 VSS.t183 587.396
R518 VSS.n397 VSS.t104 519.422
R519 VSS.n533 VSS.t159 485.825
R520 VSS.n452 VSS.n451 436.325
R521 VSS.t156 VSS.n38 425.995
R522 VSS.t52 VSS.t5 353.002
R523 VSS.n236 VSS.t86 352.661
R524 VSS.n395 VSS.t258 305.108
R525 VSS.t38 VSS.n400 293.699
R526 VSS.n400 VSS.t42 293.699
R527 VSS.n324 VSS.n315 293.539
R528 VSS.n325 VSS.n324 293.539
R529 VSS.n325 VSS.n312 293.539
R530 VSS.n315 VSS.n312 293.539
R531 VSS.n427 VSS.n160 293.539
R532 VSS.n417 VSS.n160 293.539
R533 VSS.n417 VSS.n159 293.539
R534 VSS.n427 VSS.n159 293.539
R535 VSS.n195 VSS.t59 280.966
R536 VSS.n356 VSS.n281 272.724
R537 VSS.n356 VSS.n307 272.724
R538 VSS.t87 VSS.t86 266.433
R539 VSS.t106 VSS.t64 265.464
R540 VSS.n401 VSS.n399 258.918
R541 VSS.n412 VSS.n411 258.918
R542 VSS.n532 VSS.t54 246.502
R543 VSS.t25 VSS.t23 244.15
R544 VSS.t27 VSS.t29 244.15
R545 VSS.t29 VSS.t241 244.15
R546 VSS.n334 VSS.n266 240.119
R547 VSS.n437 VSS.n150 240.119
R548 VSS.n429 VSS.n428 237.852
R549 VSS.n369 VSS.n266 235.513
R550 VSS.n437 VSS.n151 235.513
R551 VSS.n51 VSS.n31 225.659
R552 VSS.n84 VSS.n31 225.659
R553 VSS.n387 VSS.n261 225.659
R554 VSS.n386 VSS.n261 225.659
R555 VSS.n448 VSS.n120 225.659
R556 VSS.n230 VSS.n120 225.659
R557 VSS.n217 VSS.t238 220.898
R558 VSS.n306 VSS.t10 217.023
R559 VSS.t50 VSS.n280 211.8
R560 VSS.n216 VSS.t318 207.333
R561 VSS.n229 VSS.t90 196.534
R562 VSS.n275 VSS.n265 195.725
R563 VSS.n338 VSS.n275 195.725
R564 VSS.n218 VSS.n158 195.725
R565 VSS.n430 VSS.n158 195.725
R566 VSS.n359 VSS.n281 194.066
R567 VSS.n307 VSS.n109 194.066
R568 VSS.n97 VSS.t48 186.673
R569 VSS.n97 VSS.t156 177.1
R570 VSS.n417 VSS.t255 172.691
R571 VSS.n236 VSS.t180 172.456
R572 VSS.n428 VSS.t252 172.456
R573 VSS.n544 VSS.n35 169.29
R574 VSS.n35 VSS.n30 169.29
R575 VSS.n34 VSS.n30 169.29
R576 VSS.n544 VSS.n34 169.29
R577 VSS.n460 VSS.n121 169.29
R578 VSS.n460 VSS.n122 169.29
R579 VSS.n445 VSS.n121 169.29
R580 VSS.n445 VSS.n122 169.29
R581 VSS.n58 VSS.n57 169.29
R582 VSS.n59 VSS.n58 169.29
R583 VSS.n534 VSS.n59 169.29
R584 VSS.n534 VSS.n57 169.29
R585 VSS.n402 VSS.n169 163.488
R586 VSS.n402 VSS.n170 163.488
R587 VSS.n410 VSS.n170 163.488
R588 VSS.n410 VSS.n169 163.488
R589 VSS.n360 VSS.n110 157.225
R590 VSS.n546 VSS.n29 155.013
R591 VSS.n546 VSS.n28 155.013
R592 VSS.n393 VSS.n252 155.013
R593 VSS.n393 VSS.n251 155.013
R594 VSS.n231 VSS.n119 155.013
R595 VSS.n447 VSS.n119 155.013
R596 VSS.n363 VSS.n267 154.554
R597 VSS.n363 VSS.n274 154.554
R598 VSS.n215 VSS.n214 154.554
R599 VSS.n214 VSS.n157 154.554
R600 VSS.n504 VSS.n110 152.619
R601 VSS.n280 VSS.t52 151.97
R602 VSS.n533 VSS.t101 149.577
R603 VSS.t32 VSS.n38 149.577
R604 VSS.n306 VSS.t171 148.234
R605 VSS.t64 VSS.t89 147.266
R606 VSS.t305 VSS.t252 147.266
R607 VSS.t306 VSS.t305 147.266
R608 VSS.t307 VSS.t306 147.266
R609 VSS.t308 VSS.t307 147.266
R610 VSS.t309 VSS.t308 147.266
R611 VSS.t311 VSS.t310 147.266
R612 VSS.t312 VSS.t311 147.266
R613 VSS.t313 VSS.t312 147.266
R614 VSS.t314 VSS.t313 147.266
R615 VSS.t255 VSS.t314 147.266
R616 VSS.t87 VSS.t10 146.297
R617 VSS.t89 VSS.n205 145.046
R618 VSS.t241 VSS.t317 141.936
R619 VSS.n387 VSS.n252 141.29
R620 VSS.n386 VSS.n251 141.29
R621 VSS.n231 VSS.n230 141.29
R622 VSS.n237 VSS.n190 135.488
R623 VSS.n199 VSS.n190 135.488
R624 VSS.n199 VSS.n189 135.488
R625 VSS.n237 VSS.n189 135.488
R626 VSS.n558 VSS.n20 132.079
R627 VSS.n560 VSS.n20 132.079
R628 VSS.n569 VSS.n14 132.079
R629 VSS.n14 VSS.n11 132.079
R630 VSS.n524 VSS.n96 132.079
R631 VSS.n524 VSS.n98 132.079
R632 VSS.n531 VSS.n87 132.079
R633 VSS.n512 VSS.n87 132.079
R634 VSS.n464 VSS.n142 132.079
R635 VSS.n464 VSS.n143 132.079
R636 VSS.n491 VSS.n130 132.079
R637 VSS.n493 VSS.n130 132.079
R638 VSS.t320 VSS.t103 130.794
R639 VSS.t320 VSS.n205 122.442
R640 VSS.n149 VSS.t25 122.076
R641 VSS.t35 VSS.n167 120.472
R642 VSS.t159 VSS.n532 117.269
R643 VSS.n463 VSS.n462 113.356
R644 VSS.t75 VSS.t238 106.573
R645 VSS.n370 VSS.n262 102.582
R646 VSS.t274 VSS.t276 98.823
R647 VSS.t126 VSS.t280 98.823
R648 VSS.t3 VSS.t107 98.823
R649 VSS.t4 VSS.t108 98.823
R650 VSS.t108 VSS.t129 98.823
R651 VSS.t290 VSS.t292 98.823
R652 VSS.t292 VSS.t294 98.823
R653 VSS.t298 VSS.t300 98.823
R654 VSS.t300 VSS.t302 98.823
R655 VSS.n232 VSS.n195 87.1968
R656 VSS.t262 VSS.n235 86.023
R657 VSS.n233 VSS.t304 86.023
R658 VSS.n463 VSS.t103 84.7747
R659 VSS.t75 VSS.n461 84.7747
R660 VSS.n462 VSS.t318 83.8058
R661 VSS.n369 VSS.n267 83.2637
R662 VSS.n334 VSS.n274 83.2637
R663 VSS.n360 VSS.n359 83.2637
R664 VSS.n504 VSS.n109 83.2637
R665 VSS.n157 VSS.n151 83.2637
R666 VSS.n215 VSS.n150 83.2637
R667 VSS.t102 VSS.t288 82.3526
R668 VSS.t107 VSS.t165 81.3837
R669 VSS.n439 VSS.t27 79.446
R670 VSS.n429 VSS.t317 78.9616
R671 VSS.t123 VSS.t58 78.4772
R672 VSS.n576 VSS.n10 75.2505
R673 VSS.n10 VSS.n5 75.2505
R674 VSS.n9 VSS.n5 75.2505
R675 VSS.n576 VSS.n9 75.2505
R676 VSS.n578 VSS.n4 75.2505
R677 VSS.n7 VSS.n4 75.2505
R678 VSS.n7 VSS.n3 75.2505
R679 VSS.n578 VSS.n3 75.2505
R680 VSS.n315 VSS.t144 74.6133
R681 VSS.n397 VSS.t265 74.0466
R682 VSS.t89 VSS.n167 74.0466
R683 VSS.t310 VSS.n416 73.6329
R684 VSS.n33 VSS.n13 73.4084
R685 VSS.n33 VSS.n21 73.4084
R686 VSS.n526 VSS.n94 73.4084
R687 VSS.n526 VSS.n88 73.4084
R688 VSS.n498 VSS.n123 73.4084
R689 VSS.n498 VSS.n124 73.4084
R690 VSS.t59 VSS.t90 71.6952
R691 VSS.n359 VSS.n358 71.6584
R692 VSS.n358 VSS.n109 71.6584
R693 VSS.n229 VSS.t106 70.9535
R694 VSS.t48 VSS.t31 70.6007
R695 VSS.t276 VSS.t12 69.7575
R696 VSS.n502 VSS.t298 68.7887
R697 VSS.t105 VSS.t296 64.9133
R698 VSS.n217 VSS.n216 64.9133
R699 VSS.t144 VSS.t91 63.513
R700 VSS.t91 VSS.t92 63.513
R701 VSS.t92 VSS.t93 63.513
R702 VSS.t97 VSS.t98 63.513
R703 VSS.t100 VSS.t147 63.513
R704 VSS.n22 VSS.t216 61.3194
R705 VSS.n16 VSS.t222 61.3194
R706 VSS.n518 VSS.t151 61.3194
R707 VSS.n100 VSS.t153 61.3194
R708 VSS.n440 VSS.t196 61.3194
R709 VSS.n140 VSS.t206 61.3194
R710 VSS.n415 VSS.t315 59.8015
R711 VSS.n558 VSS.n13 58.6716
R712 VSS.n569 VSS.n13 58.6716
R713 VSS.n560 VSS.n21 58.6716
R714 VSS.n21 VSS.n11 58.6716
R715 VSS.n531 VSS.n88 58.6716
R716 VSS.n98 VSS.n88 58.6716
R717 VSS.n512 VSS.n94 58.6716
R718 VSS.n96 VSS.n94 58.6716
R719 VSS.n142 VSS.n123 58.6716
R720 VSS.n491 VSS.n123 58.6716
R721 VSS.n143 VSS.n124 58.6716
R722 VSS.n493 VSS.n124 58.6716
R723 VSS.t1 VSS.t100 57.4542
R724 VSS.t98 VSS.t45 55.7828
R725 VSS.n461 VSS.t23 52.8027
R726 VSS.n371 VSS.n105 52.649
R727 VSS.n22 VSS.t218 51.6309
R728 VSS.n507 VSS.t128 51.6309
R729 VSS.n518 VSS.t149 51.6309
R730 VSS.n100 VSS.t131 51.6309
R731 VSS.n508 VSS.t125 51.6309
R732 VSS.n440 VSS.t204 51.6309
R733 VSS.n140 VSS.t208 51.6309
R734 VSS.n16 VSS.t220 51.5949
R735 VSS.t302 VSS.t265 51.3494
R736 VSS.t278 VSS.n361 49.4117
R737 VSS.n361 VSS.t280 49.4117
R738 VSS.n503 VSS.t288 49.4117
R739 VSS.n503 VSS.t290 49.4117
R740 VSS.n162 VSS.t251 48.1738
R741 VSS.n310 VSS.t146 48.1738
R742 VSS.n420 VSS.t254 48.1727
R743 VSS.n320 VSS.t143 48.1727
R744 VSS.n235 VSS.n234 47.7212
R745 VSS.n234 VSS.n233 47.7212
R746 VSS.t171 VSS.t265 47.474
R747 VSS.n394 VSS.t94 47.217
R748 VSS.t34 VSS.t47 46.3813
R749 VSS.t168 VSS.t266 42.6207
R750 VSS.t270 VSS.t272 42.6207
R751 VSS.n267 VSS.n265 41.1716
R752 VSS.n338 VSS.n274 41.1716
R753 VSS.n430 VSS.n157 41.1716
R754 VSS.n218 VSS.n215 41.1716
R755 VSS.n304 VSS.t3 40.6921
R756 VSS.n446 VSS.t116 40.6779
R757 VSS.n73 VSS.t214 40.6779
R758 VSS.n40 VSS.n39 40.3131
R759 VSS.n313 VSS.t97 39.4869
R760 VSS.n416 VSS.n415 39.2388
R761 VSS.n305 VSS.t4 37.3011
R762 VSS.t34 VSS.t162 37.1887
R763 VSS.n205 VSS.n142 36.5728
R764 VSS.n415 VSS.t309 34.3946
R765 VSS.t294 VSS.t105 33.9102
R766 VSS.n362 VSS.t50 33.5057
R767 VSS.n46 VSS.t233 33.4124
R768 VSS.n43 VSS.t229 33.4124
R769 VSS.n256 VSS.t113 33.4124
R770 VSS.n259 VSS.t133 33.4124
R771 VSS.n378 VSS.t135 33.4124
R772 VSS.n381 VSS.t137 33.4124
R773 VSS.n485 VSS.t118 33.4124
R774 VSS.n482 VSS.t185 33.4124
R775 VSS.n474 VSS.t187 33.4124
R776 VSS.n471 VSS.t120 33.4124
R777 VSS.n79 VSS.t231 33.4124
R778 VSS.n76 VSS.t235 33.4124
R779 VSS.t116 VSS.t225 33.3815
R780 VSS.t214 VSS.t202 33.3815
R781 VSS.n26 VSS.t249 33.2585
R782 VSS.n81 VSS.t213 33.2585
R783 VSS.n469 VSS.t191 33.2585
R784 VSS.n477 VSS.t177 33.2585
R785 VSS.n480 VSS.t115 33.2585
R786 VSS.n487 VSS.t189 33.2585
R787 VSS.n41 VSS.t210 33.2585
R788 VSS.n27 VSS.t247 33.2585
R789 VSS.n383 VSS.t141 33.2585
R790 VSS.n253 VSS.t111 33.2585
R791 VSS.n391 VSS.t109 33.2585
R792 VSS.n254 VSS.t139 33.2585
R793 VSS.n462 VSS.t317 33.0167
R794 VSS.t57 VSS.t77 32.6519
R795 VSS.t84 VSS.t69 32.6519
R796 VSS.t264 VSS.t94 32.3835
R797 VSS.t96 VSS.n250 31.7567
R798 VSS.t93 VSS.t264 31.13
R799 VSS.n439 VSS.n438 30.5192
R800 VSS.n525 VSS.t268 30.2943
R801 VSS.t46 VSS.t0 30.0854
R802 VSS.t11 VSS.t168 30.0854
R803 VSS.t296 VSS.n502 30.0348
R804 VSS.n186 VSS.t179 29.9227
R805 VSS.n196 VSS.t122 29.9227
R806 VSS.n173 VSS.t182 29.9227
R807 VSS.n174 VSS.t193 29.9227
R808 VSS.t12 VSS.t278 29.0659
R809 VSS.n511 VSS.t11 28.8318
R810 VSS.t63 VSS.n229 28.3086
R811 VSS.t46 VSS.t147 26.9515
R812 VSS.n70 VSS.t201 26.1657
R813 VSS.n69 VSS.t198 26.1657
R814 VSS.n537 VSS.t158 26.1657
R815 VSS.n538 VSS.t155 26.1657
R816 VSS.n148 VSS.t227 26.1657
R817 VSS.n147 VSS.t224 26.1657
R818 VSS.n354 VSS.t170 26.1219
R819 VSS.n347 VSS.t167 26.1219
R820 VSS.n395 VSS.n250 25.0712
R821 VSS.t199 VSS.t211 24.261
R822 VSS.n492 VSS.t56 23.1666
R823 VSS.n559 VSS.t85 23.1666
R824 VSS.t8 VSS.n570 23.1666
R825 VSS.t266 VSS.t33 21.9374
R826 VSS.t257 VSS.t57 21.1601
R827 VSS.t5 VSS.t84 21.1601
R828 VSS.t162 VSS.n371 18.8035
R829 VSS.n499 VSS.t61 18.6063
R830 VSS.n545 VSS.t81 18.6063
R831 VSS.n545 VSS.t80 18.6063
R832 VSS.n577 VSS.t261 18.6063
R833 VSS.t2 VSS.t96 18.5946
R834 VSS.n276 VSS.t31 18.3617
R835 VSS.t18 VSS.n362 18.1007
R836 VSS.t165 VSS.t126 17.4398
R837 VSS.t0 VSS.n262 17.3411
R838 VSS.n235 VSS.t13 16.6675
R839 VSS.n233 VSS.t21 16.6675
R840 VSS.t129 VSS.t102 16.4709
R841 VSS.t95 VSS.n394 16.2965
R842 VSS.n362 VSS.n276 15.9875
R843 VSS.n450 VSS.n446 15.1405
R844 VSS.n86 VSS.n73 15.1405
R845 VSS.t180 VSS.t262 14.5332
R846 VSS.t304 VSS.t123 14.5332
R847 VSS.t73 VSS.t56 14.4109
R848 VSS.t71 VSS.t85 14.4109
R849 VSS.n492 VSS.t60 14.0461
R850 VSS.t75 VSS.t62 13.6813
R851 VSS.t65 VSS.t80 13.6813
R852 VSS.n269 VSS.t173 13.5593
R853 VSS.n331 VSS.t175 13.5593
R854 VSS.n153 VSS.t240 13.5593
R855 VSS.n207 VSS.t237 13.5593
R856 VSS.n412 VSS.n168 13.328
R857 VSS.t87 VSS.t62 13.134
R858 VSS.t7 VSS.t199 12.9516
R859 VSS.t211 VSS.t261 12.222
R860 VSS.n399 VSS.n248 12.1529
R861 VSS.n357 VSS.n305 12.1111
R862 VSS.n438 VSS.n149 12.1111
R863 VSS.t47 VSS.n370 11.7002
R864 VSS.n462 VSS.t75 11.6747
R865 VSS.n206 VSS.n168 10.8653
R866 VSS.t5 VSS.t54 10.77
R867 VSS.n70 VSS.n69 10.7105
R868 VSS.n538 VSS.n537 10.7105
R869 VSS.n148 VSS.n147 10.7105
R870 VSS.t33 VSS.t16 10.6556
R871 VSS.n246 VSS.n245 10.4478
R872 VSS.n508 VSS.n507 10.148
R873 VSS.n175 VSS.n166 10.1308
R874 VSS.t272 VSS.t18 10.0288
R875 VSS.n577 VSS.n8 9.85064
R876 VSS.t82 VSS.t6 9.66823
R877 VSS.n221 VSS.t245 8.98167
R878 VSS.n223 VSS.t243 8.98167
R879 VSS.n330 VSS.t161 8.98167
R880 VSS.n343 VSS.t164 8.98167
R881 VSS.t260 VSS.n8 8.75618
R882 VSS.n357 VSS.n304 8.72013
R883 VSS.t45 VSS.t99 7.73064
R884 VSS.t321 VSS.n450 7.66172
R885 VSS.t101 VSS.n86 7.66172
R886 VSS.n570 VSS.n12 7.66172
R887 VSS.t32 VSS.n53 7.66172
R888 VSS.n525 VSS.n95 7.10387
R889 VSS.t58 VSS.n232 6.78243
R890 VSS.n571 VSS.t31 6.74967
R891 VSS.n395 VSS.t95 6.68602
R892 VSS.n12 VSS.t7 6.38485
R893 VSS.n53 VSS.t260 6.38485
R894 VSS.t88 VSS.t268 6.26818
R895 VSS.t99 VSS.t1 6.05926
R896 VSS.n331 VSS.n269 5.71885
R897 VSS.n207 VSS.n153 5.71885
R898 VSS.t87 VSS.n499 5.4728
R899 VSS.t67 VSS.t8 5.29039
R900 VSS.t270 VSS.n95 5.22356
R901 VSS.n362 VSS.t65 5.10798
R902 VSS.n511 VSS.n105 5.01464
R903 VSS.n346 VSS.n345 4.88557
R904 VSS.n289 VSS.t169 4.8305
R905 VSS.n352 VSS.t172 4.8305
R906 VSS.n362 VSS.t274 4.67151
R907 VSS.t77 VSS.t61 4.56075
R908 VSS.t69 VSS.t81 4.56075
R909 VSS.n559 VSS.t6 4.37834
R910 VSS.n571 VSS.t67 4.01352
R911 VSS.t225 VSS.t60 3.83111
R912 VSS.t202 VSS.t82 3.83111
R913 VSS.t33 VSS.n510 3.77274
R914 VSS.t16 VSS.t88 3.76111
R915 VSS.n293 VSS.n284 3.51761
R916 VSS.n292 VSS.n285 3.51761
R917 VSS.n291 VSS.n286 3.51761
R918 VSS.n290 VSS.n287 3.51761
R919 VSS.n349 VSS.n348 3.51761
R920 VSS.n351 VSS.n350 3.51761
R921 VSS.n113 VSS.n112 3.51761
R922 VSS.n115 VSS.n114 3.51761
R923 VSS.n247 VSS.t263 3.49603
R924 VSS.n296 VSS.n283 3.47261
R925 VSS.n297 VSS.n282 3.47261
R926 VSS.n302 VSS.n298 3.47261
R927 VSS.n301 VSS.n299 3.47261
R928 VSS.n342 VSS.t166 3.15666
R929 VSS.n329 VSS.t163 3.15666
R930 VSS.n224 VSS.t244 3.15666
R931 VSS.n220 VSS.t246 3.15666
R932 VSS.n550 VSS 3.14457
R933 VSS.t264 VSS.n314 3.08945
R934 VSS.n552 VSS.n551 2.92955
R935 VSS.t44 VSS.n313 2.92542
R936 VSS.n551 VSS.n24 2.80715
R937 VSS.n355 VSS.n354 2.73366
R938 VSS VSS.n347 2.73247
R939 VSS.n136 VSS.n0 2.72525
R940 VSS.n414 VSS.t316 2.71983
R941 VSS.n226 VSS.t319 2.71983
R942 VSS.n249 VSS.t259 2.71983
R943 VSS.n75 VSS.t250 2.5835
R944 VSS.n78 VSS.t232 2.5835
R945 VSS.n77 VSS.t236 2.5835
R946 VSS.n80 VSS.t215 2.5835
R947 VSS.n470 VSS.t192 2.5835
R948 VSS.n473 VSS.t188 2.5835
R949 VSS.n472 VSS.t121 2.5835
R950 VSS.n475 VSS.t178 2.5835
R951 VSS.n481 VSS.t117 2.5835
R952 VSS.n483 VSS.t186 2.5835
R953 VSS.n484 VSS.t119 2.5835
R954 VSS.n486 VSS.t190 2.5835
R955 VSS.n42 VSS.t212 2.5835
R956 VSS.n44 VSS.t230 2.5835
R957 VSS.n45 VSS.t234 2.5835
R958 VSS.n47 VSS.t248 2.5835
R959 VSS.n382 VSS.t142 2.5835
R960 VSS.n379 VSS.t136 2.5835
R961 VSS.n380 VSS.t138 2.5835
R962 VSS.n377 VSS.t112 2.5835
R963 VSS.n260 VSS.t110 2.5835
R964 VSS.n258 VSS.t134 2.5835
R965 VSS.n257 VSS.t114 2.5835
R966 VSS.n255 VSS.t140 2.5835
R967 VSS.n164 VSS.n161 2.52168
R968 VSS.n317 VSS.n311 2.52168
R969 VSS.t2 VSS.t44 2.50757
R970 VSS.n165 VSS.n164 2.35708
R971 VSS.n318 VSS.n317 2.35708
R972 VSS.t32 VSS.n540 2.31261
R973 VSS.n457 VSS.n439 2.19516
R974 VSS.n541 VSS.t32 2.19516
R975 VSS.t101 VSS.n72 2.19516
R976 VSS.n453 VSS.t321 2.19516
R977 VSS.n424 VSS.n423 2.19366
R978 VSS.n423 VSS.n422 2.19366
R979 VSS.n67 VSS.t203 2.14866
R980 VSS.n63 VSS.t200 2.14866
R981 VSS.n520 VSS.t157 2.14866
R982 VSS.n89 VSS.t160 2.14866
R983 VSS.n323 VSS.n322 2.14866
R984 VSS.n323 VSS.n308 2.14866
R985 VSS.n129 VSS.t226 2.14866
R986 VSS.n145 VSS.t228 2.14866
R987 VSS.n248 VSS.n183 2.0805
R988 VSS.n456 VSS.n439 2.0805
R989 VSS.n226 VSS.t318 2.0805
R990 VSS.n227 VSS.t320 2.0805
R991 VSS.t89 VSS.n228 2.0805
R992 VSS.t106 VSS.n204 2.0805
R993 VSS.n203 VSS.t90 2.0805
R994 VSS.t304 VSS.n194 2.0805
R995 VSS.t262 VSS.n191 2.0805
R996 VSS.n241 VSS.t86 2.0805
R997 VSS.n243 VSS.t10 2.0805
R998 VSS.n242 VSS.t265 2.0805
R999 VSS.t105 VSS.n111 2.0805
R1000 VSS.n340 VSS.t102 2.0805
R1001 VSS.n372 VSS.t34 2.0805
R1002 VSS.t0 VSS.n373 2.0805
R1003 VSS.t1 VSS.n263 2.0805
R1004 VSS.n314 VSS.t2 2.0805
R1005 VSS.n117 VSS.t101 2.0805
R1006 VSS.t5 VSS.n279 2.0805
R1007 VSS.n277 VSS.t31 2.0805
R1008 VSS.n454 VSS.t257 2.0805
R1009 VSS.t5 VSS.n36 2.0805
R1010 VSS.n542 VSS.t31 2.0805
R1011 VSS.n571 VSS.n1 2.0805
R1012 VSS.n572 VSS.n571 2.0805
R1013 VSS.n500 VSS.t87 2.0805
R1014 VSS.n365 VSS.n271 2.06103
R1015 VSS.n273 VSS.n272 2.06103
R1016 VSS.n212 VSS.n211 2.06103
R1017 VSS.n155 VSS.n154 2.06103
R1018 VSS.n136 VSS.n118 1.98781
R1019 VSS.n333 VSS.t176 1.98608
R1020 VSS.n268 VSS.t174 1.98608
R1021 VSS.n435 VSS.t242 1.98608
R1022 VSS.n152 VSS.t239 1.98608
R1023 VSS.n300 VSS.t130 1.94108
R1024 VSS.n295 VSS.t127 1.94108
R1025 VSS.n118 VSS.n117 1.86386
R1026 VSS.n83 VSS.n25 1.81708
R1027 VSS.n50 VSS.n49 1.81708
R1028 VSS.n389 VSS.n388 1.81708
R1029 VSS.n385 VSS.n374 1.81708
R1030 VSS.n135 VSS.n133 1.81708
R1031 VSS.n138 VSS.n137 1.81708
R1032 VSS.n333 VSS.n332 1.80879
R1033 VSS.n436 VSS.n152 1.80879
R1034 VSS.n332 VSS.n268 1.74958
R1035 VSS.n436 VSS.n435 1.74958
R1036 VSS.n408 VSS.n168 1.72007
R1037 VSS.t257 VSS.t73 1.64219
R1038 VSS.t5 VSS.t71 1.64219
R1039 VSS.n322 VSS.n316 1.53642
R1040 VSS.n565 VSS.t221 1.53217
R1041 VSS.n517 VSS.t150 1.53217
R1042 VSS.n103 VSS.t132 1.53217
R1043 VSS.n132 VSS.t205 1.53217
R1044 VSS.n466 VSS.t209 1.53217
R1045 VSS.n553 VSS.t219 1.53217
R1046 VSS.n66 VSS.n60 1.51866
R1047 VSS.n64 VSS.n61 1.51866
R1048 VSS.n92 VSS.n91 1.51866
R1049 VSS.n529 VSS.n90 1.51866
R1050 VSS.n495 VSS.n128 1.51866
R1051 VSS.n127 VSS.n126 1.51866
R1052 VSS.n83 VSS.n82 1.49734
R1053 VSS.n50 VSS.n17 1.49734
R1054 VSS.n388 VSS.n99 1.49734
R1055 VSS.n385 VSS.n384 1.49734
R1056 VSS.n488 VSS.n133 1.49734
R1057 VSS.n468 VSS.n138 1.49734
R1058 VSS.n177 VSS.n176 1.48208
R1059 VSS.n180 VSS.n179 1.48208
R1060 VSS.t321 VSS.n452 1.45978
R1061 VSS.n451 VSS.t101 1.45978
R1062 VSS.t32 VSS.n40 1.45978
R1063 VSS.n418 VSS.n24 1.44642
R1064 VSS.n406 VSS.n405 1.4405
R1065 VSS.n407 VSS.n406 1.4405
R1066 VSS.n193 VSS.n192 1.43708
R1067 VSS.n327 VSS.n326 1.418
R1068 VSS.n501 VSS.n500 1.41595
R1069 VSS.n344 VSS.n343 1.38569
R1070 VSS.n223 VSS.n222 1.38569
R1071 VSS.n222 VSS.n221 1.38569
R1072 VSS.n322 VSS.n321 1.37418
R1073 VSS.n309 VSS.n308 1.37418
R1074 VSS.n426 VSS.n425 1.373
R1075 VSS.n366 VSS.n365 1.34576
R1076 VSS.n337 VSS.n273 1.34576
R1077 VSS.n212 VSS.n210 1.34576
R1078 VSS.n432 VSS.n155 1.34576
R1079 VSS.n247 VSS.n246 1.3378
R1080 VSS.n506 VSS.n106 1.33747
R1081 VSS.n424 VSS.n163 1.32918
R1082 VSS.n422 VSS.n421 1.32918
R1083 VSS.n276 VSS.t83 1.3037
R1084 VSS.n321 VSS.n320 1.29839
R1085 VSS.n421 VSS.n420 1.29839
R1086 VSS.n163 VSS.n162 1.29721
R1087 VSS.n310 VSS.n309 1.29721
R1088 VSS.n203 VSS.n202 1.2605
R1089 VSS.n241 VSS.n240 1.2605
R1090 VSS.n319 VSS.n316 1.25458
R1091 VSS.n419 VSS.n418 1.25458
R1092 VSS.n426 VSS.n161 1.25339
R1093 VSS.n326 VSS.n311 1.25339
R1094 VSS.n18 VSS.t223 1.2045
R1095 VSS.n18 VSS.t217 1.2045
R1096 VSS.n93 VSS.t152 1.2045
R1097 VSS.n93 VSS.t154 1.2045
R1098 VSS.n187 VSS.t181 1.2045
R1099 VSS.n197 VSS.t124 1.2045
R1100 VSS.n172 VSS.t184 1.2045
R1101 VSS.n181 VSS.t195 1.2045
R1102 VSS.n125 VSS.t197 1.2045
R1103 VSS.n125 VSS.t207 1.2045
R1104 VSS.n335 VSS.n333 1.18945
R1105 VSS.n368 VSS.n268 1.18945
R1106 VSS.n435 VSS.n434 1.18945
R1107 VSS.n208 VSS.n152 1.18945
R1108 VSS.n548 VSS.n547 1.16458
R1109 VSS.n500 VSS.n118 1.12674
R1110 VSS.n68 VSS.n67 1.09353
R1111 VSS.n283 VSS.t281 1.0925
R1112 VSS.n283 VSS.t284 1.0925
R1113 VSS.n282 VSS.t285 1.0925
R1114 VSS.n282 VSS.t282 1.0925
R1115 VSS.n298 VSS.t283 1.0925
R1116 VSS.n298 VSS.t286 1.0925
R1117 VSS.n299 VSS.t287 1.0925
R1118 VSS.n299 VSS.t289 1.0925
R1119 VSS.n284 VSS.t277 1.0925
R1120 VSS.n284 VSS.t279 1.0925
R1121 VSS.n285 VSS.t273 1.0925
R1122 VSS.n285 VSS.t275 1.0925
R1123 VSS.n286 VSS.t269 1.0925
R1124 VSS.n286 VSS.t271 1.0925
R1125 VSS.t169 VSS.n287 1.0925
R1126 VSS.n287 VSS.t267 1.0925
R1127 VSS.n348 VSS.t299 1.0925
R1128 VSS.n348 VSS.t301 1.0925
R1129 VSS.n351 VSS.t303 1.0925
R1130 VSS.t172 VSS.n351 1.0925
R1131 VSS.n112 VSS.t291 1.0925
R1132 VSS.n112 VSS.t293 1.0925
R1133 VSS.n114 VSS.t295 1.0925
R1134 VSS.n114 VSS.t297 1.0925
R1135 VSS.n245 VSS.n184 1.0913
R1136 VSS.n245 VSS.n244 1.0895
R1137 VSS.n294 VSS.n107 1.07103
R1138 VSS.n505 VSS.n108 1.07103
R1139 VSS.n555 VSS.n552 1.067
R1140 VSS.n547 VSS.n27 1.05866
R1141 VSS.n392 VSS.n391 1.05866
R1142 VSS.n392 VSS.n253 1.05866
R1143 VSS.n478 VSS.n477 1.05866
R1144 VSS.n82 VSS.n74 1.04261
R1145 VSS.n74 VSS.n17 1.04261
R1146 VSS.n384 VSS.n375 1.04261
R1147 VSS.n375 VSS.n99 1.04261
R1148 VSS.n468 VSS.n134 1.04261
R1149 VSS.n488 VSS.n134 1.04261
R1150 VSS.n479 VSS.n478 1.04261
R1151 VSS.n353 VSS.n307 1.0405
R1152 VSS.n307 VSS.n306 1.0405
R1153 VSS.n288 VSS.n281 1.0405
R1154 VSS.n281 VSS.n105 1.0405
R1155 VSS.n557 VSS.n556 1.03905
R1156 VSS.n63 VSS.n62 1.03432
R1157 VSS.n204 VSS.n203 1.00945
R1158 VSS.n314 VSS.n263 1.00945
R1159 VSS.n373 VSS.n263 1.00945
R1160 VSS.n373 VSS.n372 1.00945
R1161 VSS.n340 VSS.n111 1.00945
R1162 VSS.n243 VSS.n242 1.00945
R1163 VSS.n228 VSS.n227 1.00945
R1164 VSS.n501 VSS.n116 0.99674
R1165 VSS.n568 VSS.n567 0.991684
R1166 VSS.n183 VSS.n175 0.978658
R1167 VSS.n575 VSS.n574 0.968
R1168 VSS.n6 VSS.n2 0.968
R1169 VSS.n345 VSS.n344 0.964559
R1170 VSS.n510 VSS.n106 0.951421
R1171 VSS.n200 VSS.n198 0.947868
R1172 VSS.n238 VSS.n188 0.947868
R1173 VSS.n409 VSS.n171 0.944316
R1174 VSS.n403 VSS.n182 0.944316
R1175 VSS.n45 VSS.n44 0.917079
R1176 VSS.n258 VSS.n257 0.917079
R1177 VSS.n380 VSS.n379 0.917079
R1178 VSS.n240 VSS.n185 0.917079
R1179 VSS.n202 VSS.n185 0.917079
R1180 VSS.n484 VSS.n483 0.917079
R1181 VSS.n473 VSS.n472 0.917079
R1182 VSS.n78 VSS.n77 0.917079
R1183 VSS.n521 VSS.n54 0.870895
R1184 VSS.n535 VSS.n56 0.870895
R1185 VSS.n459 VSS.n146 0.870895
R1186 VSS.n444 VSS.n443 0.870895
R1187 VSS.n579 VSS.n578 0.867167
R1188 VSS.n578 VSS.n577 0.867167
R1189 VSS.n7 VSS.n6 0.867167
R1190 VSS.n577 VSS.n7 0.867167
R1191 VSS.n576 VSS.n575 0.867167
R1192 VSS.n577 VSS.n576 0.867167
R1193 VSS.n573 VSS.n5 0.867167
R1194 VSS.n577 VSS.n5 0.867167
R1195 VSS.n502 VSS.n501 0.837998
R1196 VSS.n227 VSS.n226 0.79695
R1197 VSS.n318 VSS.n249 0.786292
R1198 VSS.n414 VSS.n165 0.786292
R1199 VSS.n551 VSS.n550 0.78395
R1200 VSS.n172 VSS.n171 0.782079
R1201 VSS.n182 VSS.n181 0.782079
R1202 VSS.n575 VSS.n572 0.755002
R1203 VSS.n6 VSS.n1 0.755002
R1204 VSS.n514 VSS.n513 0.754842
R1205 VSS.n515 VSS.n514 0.754842
R1206 VSS.n139 VSS.n131 0.754842
R1207 VSS.n490 VSS.n131 0.754842
R1208 VSS.n557 VSS.n15 0.754842
R1209 VSS.n568 VSS.n15 0.754842
R1210 VSS.n562 VSS.n561 0.754842
R1211 VSS.n563 VSS.n562 0.754842
R1212 VSS.n67 VSS.n66 0.753658
R1213 VSS.n64 VSS.n63 0.753658
R1214 VSS.n219 VSS.n218 0.743357
R1215 VSS.n218 VSS.n217 0.743357
R1216 VSS.n431 VSS.n430 0.743357
R1217 VSS.n430 VSS.n429 0.743357
R1218 VSS.n339 VSS.n338 0.743357
R1219 VSS.n338 VSS.n304 0.743357
R1220 VSS.n270 VSS.n265 0.743357
R1221 VSS.n370 VSS.n265 0.743357
R1222 VSS.n374 VSS.n251 0.743357
R1223 VSS.n313 VSS.n251 0.743357
R1224 VSS.n389 VSS.n252 0.743357
R1225 VSS.n313 VSS.n252 0.743357
R1226 VSS.n28 VSS.n25 0.743357
R1227 VSS.n49 VSS.n29 0.743357
R1228 VSS.n3 VSS.n1 0.743357
R1229 VSS.n12 VSS.n3 0.743357
R1230 VSS.n4 VSS.n2 0.743357
R1231 VSS.n39 VSS.n4 0.743357
R1232 VSS.n572 VSS.n9 0.743357
R1233 VSS.n12 VSS.n9 0.743357
R1234 VSS.n574 VSS.n10 0.743357
R1235 VSS.n39 VSS.n10 0.743357
R1236 VSS.n447 VSS.n135 0.743357
R1237 VSS.n231 VSS.n137 0.743357
R1238 VSS.n232 VSS.n231 0.743357
R1239 VSS.n52 VSS.n29 0.738846
R1240 VSS.n85 VSS.n28 0.738846
R1241 VSS.n449 VSS.n447 0.738846
R1242 VSS.n188 VSS.n187 0.737079
R1243 VSS.n198 VSS.n197 0.737079
R1244 VSS.n574 VSS.n573 0.731158
R1245 VSS.n579 VSS.n2 0.731158
R1246 VSS.n49 VSS.n48 0.72353
R1247 VSS.n376 VSS.n374 0.72353
R1248 VSS.n476 VSS.n137 0.72353
R1249 VSS.n390 VSS.n389 0.72353
R1250 VSS.n550 VSS.n549 0.7196
R1251 VSS.n479 VSS.n135 0.707474
R1252 VSS.n187 VSS.n186 0.70629
R1253 VSS.n197 VSS.n196 0.70629
R1254 VSS.n173 VSS.n172 0.70629
R1255 VSS.n181 VSS.n174 0.70629
R1256 VSS.n549 VSS.n25 0.699184
R1257 VSS.n290 VSS.n289 0.687154
R1258 VSS.n352 VSS.n350 0.687154
R1259 VSS.n528 VSS.n527 0.680381
R1260 VSS.n497 VSS.n496 0.680381
R1261 VSS.n32 VSS.n15 0.680381
R1262 VSS.n565 VSS.n564 0.673132
R1263 VSS.n517 VSS.n516 0.673132
R1264 VSS.n104 VSS.n103 0.673132
R1265 VSS.n489 VSS.n132 0.673132
R1266 VSS.n467 VSS.n466 0.673132
R1267 VSS.n553 VSS.n19 0.673132
R1268 VSS.n177 VSS.n171 0.663658
R1269 VSS.n182 VSS.n180 0.663658
R1270 VSS.n201 VSS.n200 0.662474
R1271 VSS.n239 VSS.n238 0.662474
R1272 VSS.n271 VSS.t15 0.6557
R1273 VSS.n271 VSS.t17 0.6557
R1274 VSS.n272 VSS.t19 0.6557
R1275 VSS.n272 VSS.t20 0.6557
R1276 VSS.n211 VSS.t24 0.6557
R1277 VSS.n211 VSS.t26 0.6557
R1278 VSS.n154 VSS.t28 0.6557
R1279 VSS.n154 VSS.t30 0.6557
R1280 VSS.n552 VSS.n23 0.64925
R1281 VSS.n354 VSS.n353 0.640782
R1282 VSS.n341 VSS.n340 0.621026
R1283 VSS.n567 VSS.n566 0.612737
R1284 VSS.n523 VSS.n522 0.612737
R1285 VSS.n102 VSS.n101 0.612737
R1286 VSS.n442 VSS.n441 0.612737
R1287 VSS.n465 VSS.n141 0.612737
R1288 VSS.n405 VSS.n404 0.593789
R1289 VSS.n408 VSS.n407 0.593789
R1290 VSS.n368 VSS.n367 0.578395
R1291 VSS.n336 VSS.n335 0.578395
R1292 VSS.n434 VSS.n433 0.578395
R1293 VSS.n209 VSS.n208 0.578395
R1294 VSS.n372 VSS.n264 0.57129
R1295 VSS.n421 VSS.t256 0.5675
R1296 VSS.n163 VSS.t253 0.5675
R1297 VSS.n309 VSS.t148 0.5675
R1298 VSS.n321 VSS.t145 0.5675
R1299 VSS.n555 VSS.n554 0.553526
R1300 VSS.n365 VSS.n364 0.552342
R1301 VSS.n364 VSS.n273 0.552342
R1302 VSS.n213 VSS.n212 0.552342
R1303 VSS.n213 VSS.n155 0.552342
R1304 VSS.n539 VSS.n54 0.541684
R1305 VSS.n509 VSS.n107 0.531026
R1306 VSS.n506 VSS.n505 0.531026
R1307 VSS.n366 VSS.n270 0.529842
R1308 VSS.n339 VSS.n337 0.529842
R1309 VSS.n341 VSS.n339 0.529842
R1310 VSS.n432 VSS.n431 0.529842
R1311 VSS.n219 VSS.n210 0.529842
R1312 VSS.n225 VSS.n219 0.529842
R1313 VSS.n515 VSS.n96 0.5205
R1314 VSS.n511 VSS.n96 0.5205
R1315 VSS.n513 VSS.n512 0.5205
R1316 VSS.n512 VSS.n511 0.5205
R1317 VSS.n519 VSS.n98 0.5205
R1318 VSS.n98 VSS.n97 0.5205
R1319 VSS.n531 VSS.n530 0.5205
R1320 VSS.n532 VSS.n531 0.5205
R1321 VSS.n491 VSS.n490 0.5205
R1322 VSS.n492 VSS.n491 0.5205
R1323 VSS.n142 VSS.n139 0.5205
R1324 VSS.n494 VSS.n493 0.5205
R1325 VSS.n493 VSS.n492 0.5205
R1326 VSS.n144 VSS.n143 0.5205
R1327 VSS.n216 VSS.n143 0.5205
R1328 VSS.n569 VSS.n568 0.5205
R1329 VSS.n570 VSS.n569 0.5205
R1330 VSS.n558 VSS.n557 0.5205
R1331 VSS.n559 VSS.n558 0.5205
R1332 VSS.n563 VSS.n11 0.5205
R1333 VSS.n570 VSS.n11 0.5205
R1334 VSS.n561 VSS.n560 0.5205
R1335 VSS.n560 VSS.n559 0.5205
R1336 VSS.n573 VSS.n572 0.51816
R1337 VSS.n579 VSS.n1 0.51816
R1338 VSS.n246 VSS.n183 0.50185
R1339 VSS.n71 VSS.n68 0.494316
R1340 VSS.n62 VSS.n37 0.494316
R1341 VSS.n536 VSS.n535 0.494316
R1342 VSS.n459 VSS.n458 0.494316
R1343 VSS.n367 VSS.n366 0.493132
R1344 VSS.n337 VSS.n336 0.493132
R1345 VSS.n433 VSS.n432 0.493132
R1346 VSS.n210 VSS.n209 0.493132
R1347 VSS.n328 VSS.n327 0.491947
R1348 VSS.n297 VSS.n296 0.483658
R1349 VSS.n302 VSS.n301 0.483658
R1350 VSS.n444 VSS.n23 0.470632
R1351 VSS.n47 VSS.n46 0.462342
R1352 VSS.n43 VSS.n42 0.462342
R1353 VSS.n256 VSS.n255 0.462342
R1354 VSS.n260 VSS.n259 0.462342
R1355 VSS.n378 VSS.n377 0.462342
R1356 VSS.n382 VSS.n381 0.462342
R1357 VSS.n486 VSS.n485 0.462342
R1358 VSS.n482 VSS.n481 0.462342
R1359 VSS.n475 VSS.n474 0.462342
R1360 VSS.n471 VSS.n470 0.462342
R1361 VSS.n80 VSS.n79 0.462342
R1362 VSS.n76 VSS.n75 0.462342
R1363 VSS.n540 VSS.n539 0.458789
R1364 VSS.n242 VSS.n184 0.446947
R1365 VSS.n244 VSS.n243 0.446947
R1366 VSS.n510 VSS.n509 0.445763
R1367 VSS.n244 VSS.n241 0.444579
R1368 VSS.n184 VSS.n111 0.444579
R1369 VSS.n522 VSS.n521 0.439842
R1370 VSS.n101 VSS.n56 0.439842
R1371 VSS.n443 VSS.n442 0.439842
R1372 VSS.n146 VSS.n141 0.439842
R1373 VSS.n403 VSS.n402 0.433833
R1374 VSS.n402 VSS.n401 0.433833
R1375 VSS.n410 VSS.n409 0.433833
R1376 VSS.n411 VSS.n410 0.433833
R1377 VSS.n238 VSS.n237 0.433833
R1378 VSS.n237 VSS.n236 0.433833
R1379 VSS.n200 VSS.n199 0.433833
R1380 VSS.n199 VSS.n195 0.433833
R1381 VSS.n535 VSS.n534 0.433833
R1382 VSS.n534 VSS.n533 0.433833
R1383 VSS.n58 VSS.n54 0.433833
R1384 VSS.n58 VSS.n38 0.433833
R1385 VSS.n68 VSS.n34 0.433833
R1386 VSS.n73 VSS.n34 0.433833
R1387 VSS.n62 VSS.n35 0.433833
R1388 VSS.n35 VSS.n8 0.433833
R1389 VSS.n460 VSS.n459 0.433833
R1390 VSS.n461 VSS.n460 0.433833
R1391 VSS.n445 VSS.n444 0.433833
R1392 VSS.n446 VSS.n445 0.433833
R1393 VSS.n345 VSS.n330 0.420675
R1394 VSS.n60 VSS.t72 0.41
R1395 VSS.n60 VSS.t70 0.41
R1396 VSS.n61 VSS.t66 0.41
R1397 VSS.n61 VSS.t68 0.41
R1398 VSS.n91 VSS.t51 0.41
R1399 VSS.n91 VSS.t49 0.41
R1400 VSS.n90 VSS.t55 0.41
R1401 VSS.n90 VSS.t53 0.41
R1402 VSS.n128 VSS.t78 0.41
R1403 VSS.n128 VSS.t74 0.41
R1404 VSS.n126 VSS.t76 0.41
R1405 VSS.n126 VSS.t79 0.41
R1406 VSS.n226 VSS.n225 0.408529
R1407 VSS.n329 VSS.n328 0.407868
R1408 VSS.n220 VSS.n156 0.407868
R1409 VSS.n567 VSS.n16 0.401
R1410 VSS.n404 VSS.n175 0.398395
R1411 VSS.n293 VSS.n292 0.393658
R1412 VSS.n292 VSS.n291 0.393658
R1413 VSS.n291 VSS.n290 0.393658
R1414 VSS.n350 VSS.n349 0.393658
R1415 VSS.n115 VSS.n113 0.393658
R1416 VSS.n65 VSS.n64 0.390105
R1417 VSS.n228 VSS.n206 0.388921
R1418 VSS.n206 VSS.n204 0.384184
R1419 VSS.n42 VSS.n41 0.381839
R1420 VSS.n255 VSS.n254 0.381839
R1421 VSS.n383 VSS.n382 0.381839
R1422 VSS.n487 VSS.n486 0.381839
R1423 VSS.n481 VSS.n480 0.381839
R1424 VSS.n470 VSS.n469 0.381839
R1425 VSS.n81 VSS.n80 0.381839
R1426 VSS.n75 VSS.n26 0.381839
R1427 VSS.n288 VSS.n264 0.368414
R1428 VSS.n48 VSS.n47 0.365237
R1429 VSS.n44 VSS.n43 0.365237
R1430 VSS.n46 VSS.n45 0.365237
R1431 VSS.n259 VSS.n258 0.365237
R1432 VSS.n257 VSS.n256 0.365237
R1433 VSS.n390 VSS.n260 0.365237
R1434 VSS.n377 VSS.n376 0.365237
R1435 VSS.n379 VSS.n378 0.365237
R1436 VSS.n381 VSS.n380 0.365237
R1437 VSS.n483 VSS.n482 0.365237
R1438 VSS.n485 VSS.n484 0.365237
R1439 VSS.n476 VSS.n475 0.365237
R1440 VSS.n474 VSS.n473 0.365237
R1441 VSS.n472 VSS.n471 0.365237
R1442 VSS.n79 VSS.n78 0.365237
R1443 VSS.n77 VSS.n76 0.365237
R1444 VSS.n193 VSS.n189 0.347167
R1445 VSS.n234 VSS.n189 0.347167
R1446 VSS.n190 VSS.n185 0.347167
R1447 VSS.n234 VSS.n190 0.347167
R1448 VSS.n102 VSS.n87 0.347167
R1449 VSS.n525 VSS.n87 0.347167
R1450 VSS.n527 VSS.n526 0.347167
R1451 VSS.n526 VSS.n525 0.347167
R1452 VSS.n524 VSS.n523 0.347167
R1453 VSS.n525 VSS.n524 0.347167
R1454 VSS.n110 VSS.n106 0.347167
R1455 VSS.n305 VSS.n110 0.347167
R1456 VSS.n566 VSS.n14 0.347167
R1457 VSS.n40 VSS.n14 0.347167
R1458 VSS.n498 VSS.n497 0.347167
R1459 VSS.n499 VSS.n498 0.347167
R1460 VSS.n441 VSS.n130 0.347167
R1461 VSS.n452 VSS.n130 0.347167
R1462 VSS.n465 VSS.n464 0.347167
R1463 VSS.n464 VSS.n463 0.347167
R1464 VSS.n554 VSS.n20 0.347167
R1465 VSS.n451 VSS.n20 0.347167
R1466 VSS.n33 VSS.n32 0.347167
R1467 VSS.n545 VSS.n33 0.347167
R1468 VSS.n71 VSS.n70 0.34475
R1469 VSS.n522 VSS.n518 0.34475
R1470 VSS.n537 VSS.n536 0.34475
R1471 VSS.n101 VSS.n100 0.34475
R1472 VSS.n442 VSS.n440 0.34475
R1473 VSS.n141 VSS.n140 0.34475
R1474 VSS.n66 VSS.n65 0.330895
R1475 VSS.n147 VSS.n23 0.3305
R1476 VSS.n336 VSS.n331 0.32935
R1477 VSS.n367 VSS.n269 0.32935
R1478 VSS.n209 VSS.n207 0.32935
R1479 VSS.n433 VSS.n153 0.32935
R1480 VSS.n192 VSS.t14 0.3281
R1481 VSS.n192 VSS.t22 0.3281
R1482 VSS.n176 VSS.t43 0.3281
R1483 VSS.n176 VSS.t41 0.3281
R1484 VSS.n179 VSS.t37 0.3281
R1485 VSS.n179 VSS.t39 0.3281
R1486 VSS.n178 VSS.n177 0.3155
R1487 VSS.n180 VSS 0.314316
R1488 VSS.n208 VSS.n150 0.306382
R1489 VSS.n217 VSS.n150 0.306382
R1490 VSS.n434 VSS.n151 0.306382
R1491 VSS.n429 VSS.n151 0.306382
R1492 VSS.n335 VSS.n334 0.306382
R1493 VSS.n334 VSS.n304 0.306382
R1494 VSS.n369 VSS.n368 0.306382
R1495 VSS.n370 VSS.n369 0.306382
R1496 VSS.n360 VSS.n107 0.306382
R1497 VSS.n361 VSS.n360 0.306382
R1498 VSS.n505 VSS.n504 0.306382
R1499 VSS.n504 VSS.n503 0.306382
R1500 VSS.n514 VSS.n93 0.302706
R1501 VSS.n131 VSS.n125 0.302706
R1502 VSS.n562 VSS.n18 0.302706
R1503 VSS.n556 VSS.n22 0.302
R1504 VSS.n69 VSS.n37 0.2885
R1505 VSS.n458 VSS.n148 0.2885
R1506 VSS.n509 VSS.n508 0.2885
R1507 VSS.n507 VSS.n506 0.2885
R1508 VSS.n513 VSS.n104 0.288263
R1509 VSS.n516 VSS.n515 0.288263
R1510 VSS.n467 VSS.n139 0.288263
R1511 VSS.n490 VSS.n489 0.288263
R1512 VSS.n561 VSS.n19 0.288263
R1513 VSS.n564 VSS.n563 0.288263
R1514 VSS.n566 VSS.n565 0.281158
R1515 VSS.n523 VSS.n517 0.281158
R1516 VSS.n103 VSS.n102 0.281158
R1517 VSS.n441 VSS.n132 0.281158
R1518 VSS.n466 VSS.n465 0.281158
R1519 VSS.n554 VSS.n553 0.281158
R1520 VSS VSS.n156 0.271684
R1521 VSS.n425 VSS 0.265763
R1522 VSS.n178 VSS.n169 0.248119
R1523 VSS.n400 VSS.n169 0.248119
R1524 VSS.n406 VSS.n170 0.248119
R1525 VSS.n400 VSS.n170 0.248119
R1526 VSS.n528 VSS.n57 0.248119
R1527 VSS.n280 VSS.n57 0.248119
R1528 VSS.n278 VSS.n59 0.248119
R1529 VSS.n280 VSS.n59 0.248119
R1530 VSS.n455 VSS.n122 0.248119
R1531 VSS.n499 VSS.n122 0.248119
R1532 VSS.n544 VSS.n543 0.248119
R1533 VSS.n545 VSS.n544 0.248119
R1534 VSS.n65 VSS.n30 0.248119
R1535 VSS.n545 VSS.n30 0.248119
R1536 VSS.n496 VSS.n121 0.248119
R1537 VSS.n499 VSS.n121 0.248119
R1538 VSS.n539 VSS.n538 0.24575
R1539 VSS.n303 VSS.n297 0.242079
R1540 VSS.n303 VSS.n302 0.242079
R1541 VSS.n328 VSS.n270 0.240895
R1542 VSS.n431 VSS.n156 0.240895
R1543 VSS.n541 VSS.n37 0.237342
R1544 VSS.n72 VSS.n71 0.237342
R1545 VSS.n536 VSS.n55 0.237342
R1546 VSS.n458 VSS.n457 0.237342
R1547 VSS.n427 VSS.n426 0.236864
R1548 VSS.n428 VSS.n427 0.236864
R1549 VSS.n418 VSS.n417 0.236864
R1550 VSS.n316 VSS.n315 0.236864
R1551 VSS.n326 VSS.n325 0.236864
R1552 VSS.n325 VSS.n262 0.236864
R1553 VSS.n393 VSS.n392 0.226587
R1554 VSS.n394 VSS.n393 0.226587
R1555 VSS.n375 VSS.n261 0.226587
R1556 VSS.n371 VSS.n261 0.226587
R1557 VSS.n74 VSS.n31 0.226587
R1558 VSS.n545 VSS.n31 0.226587
R1559 VSS.n547 VSS.n546 0.226587
R1560 VSS.n546 VSS.n545 0.226587
R1561 VSS.n478 VSS.n119 0.226587
R1562 VSS.n499 VSS.n119 0.226587
R1563 VSS.n134 VSS.n120 0.226587
R1564 VSS.n499 VSS.n120 0.226587
R1565 VSS.n72 VSS.n36 0.220602
R1566 VSS.n279 VSS.n55 0.220602
R1567 VSS.n454 VSS.n453 0.220602
R1568 VSS.n386 VSS.n385 0.217167
R1569 VSS.t46 VSS.n386 0.217167
R1570 VSS.n388 VSS.n387 0.217167
R1571 VSS.n387 VSS.t46 0.217167
R1572 VSS.n84 VSS.n83 0.217167
R1573 VSS.n51 VSS.n50 0.217167
R1574 VSS.n448 VSS.n133 0.217167
R1575 VSS.n230 VSS.n138 0.217167
R1576 VSS.n230 VSS.t63 0.217167
R1577 VSS.n85 VSS.n84 0.216205
R1578 VSS.n52 VSS.n51 0.216205
R1579 VSS.n449 VSS.n448 0.216205
R1580 VSS.n453 VSS.n23 0.213658
R1581 VSS.n248 VSS.n247 0.212488
R1582 VSS.n425 VSS.n424 0.208921
R1583 VSS.n349 VSS.n116 0.199447
R1584 VSS.n542 VSS 0.198255
R1585 VSS.n277 VSS 0.198255
R1586 VSS VSS.n456 0.198255
R1587 VSS.n347 VSS.n346 0.194822
R1588 VSS VSS.n0 0.187925
R1589 VSS.n343 VSS.n342 0.180168
R1590 VSS.n330 VSS.n329 0.180168
R1591 VSS.n224 VSS.n223 0.180168
R1592 VSS.n221 VSS.n220 0.180168
R1593 VSS.n479 VSS.n136 0.166727
R1594 VSS.n295 VSS.n294 0.163921
R1595 VSS.n300 VSS.n108 0.163921
R1596 VSS.n202 VSS.n201 0.163921
R1597 VSS.n240 VSS.n239 0.163921
R1598 VSS.n319 VSS.n318 0.163921
R1599 VSS.n419 VSS.n165 0.163921
R1600 VSS.n437 VSS.n436 0.153441
R1601 VSS.n438 VSS.n437 0.153441
R1602 VSS.n214 VSS.n213 0.153441
R1603 VSS.n214 VSS.n149 0.153441
R1604 VSS.n222 VSS.n158 0.153441
R1605 VSS.n158 VSS.n149 0.153441
R1606 VSS.n332 VSS.n266 0.153441
R1607 VSS.n266 VSS.n95 0.153441
R1608 VSS.n364 VSS.n363 0.153441
R1609 VSS.n363 VSS.t270 0.153441
R1610 VSS.n344 VSS.n275 0.153441
R1611 VSS.t270 VSS.n275 0.153441
R1612 VSS.n294 VSS.n293 0.152079
R1613 VSS.n113 VSS.n108 0.152079
R1614 VSS.n422 VSS.n24 0.1355
R1615 VSS.n549 VSS.n548 0.130763
R1616 VSS.n543 VSS.n36 0.129684
R1617 VSS.n543 VSS.n542 0.129684
R1618 VSS.n279 VSS.n278 0.129684
R1619 VSS.n278 VSS.n277 0.129684
R1620 VSS.n456 VSS.n455 0.129684
R1621 VSS.n455 VSS.n454 0.129684
R1622 VSS.n164 VSS.n159 0.127329
R1623 VSS.n416 VSS.n159 0.127329
R1624 VSS.n423 VSS.n160 0.127329
R1625 VSS.n416 VSS.n160 0.127329
R1626 VSS.n317 VSS.n312 0.127329
R1627 VSS.n312 VSS.n250 0.127329
R1628 VSS.n324 VSS.n323 0.127329
R1629 VSS.n324 VSS.n250 0.127329
R1630 VSS.n193 VSS.n191 0.121446
R1631 VSS.n194 VSS.n193 0.121446
R1632 VSS.n162 VSS.n161 0.118921
R1633 VSS.n239 VSS.n186 0.118921
R1634 VSS.n201 VSS.n196 0.118921
R1635 VSS.n320 VSS.n319 0.118921
R1636 VSS.n327 VSS.n308 0.118921
R1637 VSS.n311 VSS.n310 0.118921
R1638 VSS.n342 VSS.n341 0.118921
R1639 VSS.n407 VSS.n173 0.118921
R1640 VSS.n405 VSS.n174 0.118921
R1641 VSS.n225 VSS.n224 0.118921
R1642 VSS.n420 VSS.n419 0.118921
R1643 VSS.n556 VSS.n555 0.107079
R1644 VSS.n116 VSS.n115 0.104711
R1645 VSS.n530 VSS.n529 0.0993344
R1646 VSS.n495 VSS.n494 0.0993344
R1647 VSS.n356 VSS.n355 0.0967963
R1648 VSS.n357 VSS.n356 0.0967963
R1649 VSS.n358 VSS.n303 0.0967963
R1650 VSS.n358 VSS.n357 0.0967963
R1651 VSS.n528 VSS.n92 0.0913282
R1652 VSS.n496 VSS.n127 0.0913282
R1653 VSS.n520 VSS.n519 0.0910521
R1654 VSS.n145 VSS.n144 0.0910521
R1655 VSS.n519 VSS.n92 0.0855307
R1656 VSS.n144 VSS.n127 0.0855307
R1657 VSS.n564 VSS.n17 0.0816765
R1658 VSS.n516 VSS.n99 0.0816765
R1659 VSS.n384 VSS.n104 0.0816765
R1660 VSS.n489 VSS.n488 0.0816765
R1661 VSS.n468 VSS.n467 0.0816765
R1662 VSS.n82 VSS.n19 0.0816765
R1663 VSS.n346 VSS.n264 0.0775855
R1664 VSS.n529 VSS.n528 0.0775245
R1665 VSS.n496 VSS.n495 0.0775245
R1666 VSS.n530 VSS.n89 0.0772485
R1667 VSS.n494 VSS.n129 0.0772485
R1668 VSS VSS.n0 0.075875
R1669 VSS.n404 VSS.n403 0.0691842
R1670 VSS.n409 VSS.n408 0.0691842
R1671 VSS.n117 VSS.n55 0.0636458
R1672 VSS.n480 VSS.n479 0.0603544
R1673 VSS.n191 VSS.n188 0.0592697
R1674 VSS.n198 VSS.n194 0.0592697
R1675 VSS.n41 VSS.n17 0.0579872
R1676 VSS.n254 VSS.n99 0.0579872
R1677 VSS.n384 VSS.n383 0.0579872
R1678 VSS.n488 VSS.n487 0.0579872
R1679 VSS.n469 VSS.n468 0.0579872
R1680 VSS.n82 VSS.n81 0.0579872
R1681 VSS.n48 VSS.n27 0.0554296
R1682 VSS.n391 VSS.n390 0.0554296
R1683 VSS.n376 VSS.n253 0.0554296
R1684 VSS.n477 VSS.n476 0.0554296
R1685 VSS.n89 VSS.n56 0.0524018
R1686 VSS.n443 VSS.n129 0.0524018
R1687 VSS.n548 VSS.n26 0.0437524
R1688 VSS.n521 VSS.n520 0.0385982
R1689 VSS.n146 VSS.n145 0.0385982
R1690 VSS.n527 VSS.n93 0.0372991
R1691 VSS.n497 VSS.n125 0.0372991
R1692 VSS.n32 VSS.n18 0.0372991
R1693 VSS.n296 VSS.n295 0.0336579
R1694 VSS.n301 VSS.n300 0.0336579
R1695 VSS VSS.n541 0.0228469
R1696 VSS.n457 VSS 0.0228469
R1697 VSS.n289 VSS.n288 0.0137143
R1698 VSS.n353 VSS.n352 0.0137143
R1699 VSS.n540 VSS 0.0112143
R1700 VSS.n65 VSS.n15 0.00759882
R1701 VSS.n573 VSS 0.004325
R1702 VSS VSS.n579 0.004325
R1703 VSS.n86 VSS.n85 0.00213148
R1704 VSS.n53 VSS.n52 0.00213148
R1705 VSS.n450 VSS.n449 0.00213148
R1706 VSS.n355 VSS 0.00168421
R1707 VSS VSS.n178 0.00168421
C0 a_19458_12220# a_22199_13400# 0.65869f
C1 a_3561_9730# a_3598_8020# 0.02791f
C2 tanh_ota_0.V_ref a_2717_9730# 0.26733f
C3 a_19914_9664# a_19458_8812# 0.08585f
C4 a_3415_6100# a_3598_8020# 0
C5 tanh_ota_0.V_ref a_13492_1131# 3.7839f
C6 a_2717_15824# I_x1 0.00197f
C7 gilbert_multiplier_current_2.V_x_n tanh_ota_0.V_in_p 0.25121f
C8 a_2717_12168# gilbert_multiplier_current_1.V_x_n 0.05238f
C9 a_9805_17650# tanh_ota_0.V_in_p 0.0388f
C10 a_8953_14522# tanh_ota_0.V_in_n 0.0011f
C11 VDD a_19458_8812# 0.07538f
C12 tanh_ota_0.V_ref voltage_reference_0.v_1_15 0.14918f
C13 I_x2 tanh_ota_0.V_in_p 0.08148f
C14 a_11555_17360# tanh_ota_0.V_in_p 0.12224f
C15 gilbert_multiplier_current_2.V_x_n a_3619_22696# 0
C16 VDD a_26642_10516# 0.08026f
C17 tanh_ota_0.V_ref a_4405_12168# 0.00372f
C18 VDD V_shift 0.05962f
C19 tanh_ota_0.V_ref a_3598_8020# 0.46973f
C20 tanh_ota_0.V_ref a_7766_18788# 0.06904f
C21 a_13330_16152# a_13330_17856# 0.00587f
C22 a_13382_20226# a_11555_17360# 0
C23 a_3415_21020# V_w1 0.65271f
C24 tanh_ota_0.V_in_p voltage_reference_0.v_1_25 0.44798f
C25 tanh_ota_0.V_ref a_9196_7474# 0.46508f
C26 a_2717_9730# a_3619_2602# 0
C27 VDD a_19854_15770# 1.69864f
C28 a_13330_9664# a_13330_11368# 0.00587f
C29 a_13382_20226# voltage_reference_0.v_1_25 1.04852f
C30 a_3619_22696# voltage_reference_0.v_1_25 0.35627f
C31 tanh_ota_0.V_ref a_7657_6436# 0.34683f
C32 gilbert_multiplier_current_1.V_x_n V_w2 0.00333f
C33 gilbert_multiplier_current_2.V_x_n a_2717_18262# 0.3651f
C34 a_2717_15824# a_4405_15824# 0.01656f
C35 a_13330_9664# a_14558_5878# 0.00953f
C36 a_13250_5878# tanh_ota_0.V_ref 0.39048f
C37 a_19458_15300# a_19458_17004# 0.0161f
C38 a_13492_24053# V_out_perceptron 0.00194f
C39 tanh_ota_0.V_ref a_14690_5774# 0.28006f
C40 a_3619_2602# a_3598_8020# 0.77598f
C41 tanh_ota_0.V_in_n V_out_perceptron 0.51062f
C42 VDD a_7311_24128# 0.2502f
C43 gilbert_multiplier_current_2.V_x_n I_x1 0.52208f
C44 VDD a_3598_19300# 0.00331f
C45 a_19458_15300# a_19467_13334# 0.00264f
C46 a_2717_18262# voltage_reference_0.v_1_25 0
C47 a_3619_22696# tanh_ota_0.V_in_p 2.13719f
C48 tanh_ota_0.V_ref a_13382_5774# 1.04852f
C49 V_b gilbert_multiplier_current_2.V_x_n 0
C50 V_shift voltage_reference_0.v_1_25 0.09992f
C51 a_11839_24980# V_out_perceptron 0.00296f
C52 a_8355_9194# voltage_reference_0.v_1_25 0.16254f
C53 a_9345_3998# a_7657_3998# 0.01656f
C54 I_x2 V_b 0.04147f
C55 voltage_reference_0.v_1_25 I_x1 0.20987f
C56 a_7311_22424# VDD 0.23421f
C57 a_8559_11644# tanh_ota_0.V_in_n 2.16944f
C58 tanh_ota_0.V_ref VDD 6.5962f
C59 gilbert_multiplier_current_2.V_x_n a_3598_19300# 0.04166f
C60 V_out_perceptron a_13330_17856# 0.00168f
C61 a_23777_13400# voltage_reference_0.v_1_15 0.84737f
C62 a_2717_18262# tanh_ota_0.V_in_p 0.31773f
C63 V_b voltage_reference_0.v_1_25 0.16024f
C64 tanh_ota_0.V_ref a_8501_6436# 0.03259f
C65 V_shift tanh_ota_0.V_in_p 0.04934f
C66 a_11839_23276# VDD 0
C67 V_w2 tanh_ota_0.V_in_n 1.33403f
C68 a_19458_10516# a_19458_12220# 0.01841f
C69 a_8355_9194# tanh_ota_0.V_in_p 2.00137f
C70 a_22199_13400# voltage_reference_0.v_1_15 1.5168f
C71 a_11839_24980# a_13492_24053# 0.00339f
C72 a_2717_18262# a_3619_22696# 0
C73 tanh_ota_0.V_ref a_7657_3998# 0.01755f
C74 gilbert_multiplier_current_1.V_x_n a_2717_9730# 0.3651f
C75 voltage_reference_0.v_1_25 a_7311_24128# 0.00294f
C76 tanh_ota_0.V_in_p I_x1 0.12114f
C77 a_13250_5878# a_13330_16152# 0.03953f
C78 a_3561_9730# voltage_reference_0.v_1_25 0
C79 a_3598_19300# voltage_reference_0.v_1_25 0.61396f
C80 V_b tanh_ota_0.V_in_p 2.43096f
C81 tanh_ota_0.V_ref gilbert_multiplier_current_2.V_x_n 0.02515f
C82 a_19458_12220# a_19467_13334# 0.01424f
C83 tanh_ota_0.V_ref a_14558_5878# 1.47413f
C84 voltage_reference_0.v_1_25 a_4405_15824# 0.02497f
C85 a_19914_7960# voltage_reference_0.v_1_15 0.03725f
C86 gilbert_multiplier_current_1.V_x_n a_3598_8020# 0.04166f
C87 a_3415_21020# tanh_ota_0.V_in_n 2.16944f
C88 a_11555_17360# a_11839_23276# 0.0161f
C89 tanh_ota_0.V_in_p a_3561_9730# 0
C90 a_3598_19300# tanh_ota_0.V_in_p 0.03585f
C91 a_7311_22424# voltage_reference_0.v_1_25 0.10628f
C92 tanh_ota_0.V_ref voltage_reference_0.v_1_25 1.59128f
C93 tanh_ota_0.V_in_p a_3415_6100# 2.58652f
C94 V_out_perceptron a_10295_19296# 0.75246f
C95 a_13330_16152# a_14558_20330# 0.0074f
C96 a_11839_23276# voltage_reference_0.v_1_25 0.05065f
C97 a_3598_19300# a_3619_22696# 0.7754f
C98 a_2717_12168# a_4405_12168# 0.01656f
C99 tanh_ota_0.V_in_p a_4405_15824# 0.00777f
C100 V_out_perceptron a_7766_18788# 2.12528f
C101 a_19458_12220# voltage_reference_0.v_1_15 0.01193f
C102 V_b a_8355_9194# 0.72896f
C103 a_7311_22424# tanh_ota_0.V_in_p 0.00479f
C104 VDD a_23777_13400# 1.45789f
C105 tanh_ota_0.V_ref tanh_ota_0.V_in_p 5.95733f
C106 a_19458_10516# a_19467_13334# 0
C107 V_b I_x1 0.02978f
C108 a_8559_11644# voltage_reference_0.v_1_15 0.16229f
C109 a_3619_2602# voltage_reference_0.v_1_25 0.16254f
C110 a_7311_22424# a_3619_22696# 0
C111 a_2717_18262# a_3598_19300# 0.23395f
C112 a_19458_15300# VDD 0.0951f
C113 VDD a_22199_13400# 1.80269f
C114 tanh_ota_0.V_ref a_3619_22696# 0.83293f
C115 gilbert_multiplier_current_2.V_x_n V_w1 0.00333f
C116 a_13250_5878# V_out_perceptron 0.13171f
C117 tanh_ota_0.V_in_n a_10295_19296# 0.17229f
C118 a_8559_11644# a_9196_7474# 0.77508f
C119 a_19914_9664# a_19914_7960# 0.0161f
C120 tanh_ota_0.V_in_n a_3598_8020# 0.03112f
C121 tanh_ota_0.V_in_n a_7766_18788# 0.47423f
C122 a_11555_17360# a_13330_16152# 0
C123 a_14690_20226# a_13492_24053# 1.10709f
C124 a_8559_11644# a_7657_6436# 0
C125 V_w1 voltage_reference_0.v_1_25 0.00333f
C126 tanh_ota_0.V_in_p a_3619_2602# 1.99792f
C127 tanh_ota_0.V_ref a_2717_18262# 0.26229f
C128 VDD a_19914_7960# 0.0373f
C129 tanh_ota_0.V_in_n a_7657_6436# 0.17076f
C130 tanh_ota_0.V_ref a_8355_9194# 0.88892f
C131 VDD V_out_perceptron 1.93991f
C132 V_w1 tanh_ota_0.V_in_p 1.09485f
C133 gilbert_multiplier_current_1.V_x_n gilbert_multiplier_current_2.V_x_n 0
C134 V_b tanh_ota_0.V_ref 4.01697f
C135 a_26642_16152# a_26642_17856# 0.0161f
C136 a_19458_12220# VDD 6.14308f
C137 V_w1 a_3619_22696# 0.71915f
C138 I_x2 gilbert_multiplier_current_1.V_x_n 0.52208f
C139 a_13492_24053# a_14558_20330# 0.03312f
C140 a_26642_8812# voltage_reference_0.v_1_15 0.02284f
C141 a_7311_22424# a_7311_24128# 0.0161f
C142 tanh_ota_0.V_ref a_9345_3998# 0.01755f
C143 a_13250_5878# a_13330_17856# 0.02924f
C144 VDD a_13492_24053# 4.32068f
C145 tanh_ota_0.V_ref a_3561_9730# 0.03093f
C146 tanh_ota_0.V_ref a_3598_19300# 0.45119f
C147 gilbert_multiplier_current_1.V_x_n voltage_reference_0.v_1_25 0.21459f
C148 a_8953_14522# tanh_ota_0.V_in_p 0.08037f
C149 a_9805_17650# V_out_perceptron 0.06311f
C150 tanh_ota_0.V_ref a_3415_6100# 0.75193f
C151 VDD tanh_ota_0.V_in_n 1.16046f
C152 a_2717_9730# a_3598_8020# 0.23395f
C153 a_11555_17360# V_out_perceptron 0.03103f
C154 a_21914_17004# a_21914_18708# 0.0161f
C155 I_x2 a_2717_12168# 0.00139f
C156 tanh_ota_0.V_ref a_4405_15824# 0.00372f
C157 a_19914_9664# a_19458_10516# 0.08585f
C158 voltage_reference_0.v_1_25 V_out_perceptron 0.09239f
C159 a_21914_17004# a_14558_20330# 0.00325f
C160 a_11839_24980# VDD 0.0475f
C161 a_19458_12220# a_14558_5878# 0.03563f
C162 a_7766_18788# a_10295_19296# 1.10067f
C163 a_2717_12168# voltage_reference_0.v_1_25 0.0064f
C164 gilbert_multiplier_current_1.V_x_n tanh_ota_0.V_in_p 0.20574f
C165 a_13330_17856# a_14558_20330# 0.01007f
C166 a_19458_17004# a_14558_20330# 0.08837f
C167 a_19458_10516# VDD 0.07587f
C168 a_26642_10516# a_23777_13400# 0
C169 a_9196_7474# voltage_reference_0.v_1_15 0.30482f
C170 a_3619_2602# a_3415_6100# 0.13501f
C171 a_9805_17650# tanh_ota_0.V_in_n 0
C172 VDD a_19458_17004# 0.09195f
C173 a_14690_5774# a_13492_1131# 1.10709f
C174 a_7657_6436# voltage_reference_0.v_1_15 0.03568f
C175 a_11555_17360# tanh_ota_0.V_in_n 0.01441f
C176 tanh_ota_0.V_in_p V_out_perceptron 0.13196f
C177 a_8953_14522# a_8355_9194# 0.00419f
C178 a_23777_13400# a_19854_15770# 0.62866f
C179 a_13250_5878# a_10295_19296# 0
C180 a_13492_24053# voltage_reference_0.v_1_25 3.7839f
C181 a_2717_12168# tanh_ota_0.V_in_p 0.00686f
C182 a_13250_5878# voltage_reference_0.v_1_15 0.08069f
C183 a_13382_5774# a_13492_1131# 0.2532f
C184 a_13382_20226# V_out_perceptron 0.00195f
C185 VDD a_19467_13334# 0.39186f
C186 tanh_ota_0.V_in_n voltage_reference_0.v_1_25 1.18253f
C187 a_14690_5774# voltage_reference_0.v_1_15 0.05968f
C188 a_7657_6436# a_9196_7474# 0.23395f
C189 a_19458_15300# a_19854_15770# 0.02115f
C190 V_w2 voltage_reference_0.v_1_25 0.00333f
C191 a_23777_13400# a_26642_16152# 0
C192 a_22199_13400# a_19854_15770# 0.77357f
C193 tanh_ota_0.V_ref a_3619_2602# 0.92892f
C194 a_8953_14522# V_b 0.01286f
C195 a_19458_10516# a_14558_5878# 0.15325f
C196 a_26642_8812# VDD 0.09804f
C197 a_13382_5774# voltage_reference_0.v_1_15 0.05166f
C198 a_19914_7960# a_19458_8812# 0.08585f
C199 a_3415_21020# gilbert_multiplier_current_2.V_x_n 0.16229f
C200 a_8559_11644# tanh_ota_0.V_in_p 2.58855f
C201 a_19914_9664# voltage_reference_0.v_1_15 0.0037f
C202 a_3561_18262# gilbert_multiplier_current_2.V_x_n 0
C203 VDD a_13492_1131# 3.92843f
C204 a_11555_17360# a_13330_17856# 0.00441f
C205 tanh_ota_0.V_in_n tanh_ota_0.V_in_p 8.79808f
C206 a_13382_20226# a_13492_24053# 0.2532f
C207 V_w2 tanh_ota_0.V_in_p 1.12751f
C208 tanh_ota_0.V_ref V_w1 3.92601f
C209 V_b gilbert_multiplier_current_1.V_x_n 0.00705f
C210 VDD voltage_reference_0.v_1_15 1.2947f
C211 tanh_ota_0.V_in_n a_3619_22696# 2.37371f
C212 a_3561_18262# voltage_reference_0.v_1_25 0
C213 VDD a_7766_18788# 7.56513f
C214 a_13250_5878# a_13382_5774# 0.70424f
C215 a_14690_20226# a_14558_20330# 0.54051f
C216 gilbert_multiplier_current_1.V_x_n a_3561_9730# 0
C217 a_13382_5774# a_14690_5774# 0.41277f
C218 a_8953_14522# tanh_ota_0.V_ref 0.02255f
C219 gilbert_multiplier_current_1.V_x_n a_3415_6100# 0.16229f
C220 a_9196_7474# a_8501_6436# 0.02724f
C221 a_13492_1131# a_14558_5878# 0.03312f
C222 a_14690_20226# VDD 6.6799f
C223 a_13250_5878# a_14558_20330# 0.22359f
C224 a_19458_12220# a_19854_15770# 0.06245f
C225 a_8559_11644# a_8355_9194# 0.13501f
C226 a_3415_21020# tanh_ota_0.V_in_p 2.72648f
C227 a_9805_17650# a_10295_19296# 0
C228 a_7657_6436# a_8501_6436# 0.02791f
C229 a_13382_20226# a_13330_17856# 0
C230 a_3561_18262# tanh_ota_0.V_in_p 0
C231 a_2717_9730# voltage_reference_0.v_1_25 0
C232 tanh_ota_0.V_in_n V_shift 0.03881f
C233 a_11555_17360# a_10295_19296# 0.17848f
C234 voltage_reference_0.v_1_15 a_14558_5878# 0.08983f
C235 tanh_ota_0.V_in_n a_8355_9194# 2.39106f
C236 a_3415_21020# a_3619_22696# 0.13501f
C237 VDD a_14690_5774# 6.6799f
C238 a_9805_17650# a_7766_18788# 0.00182f
C239 V_b a_8559_11644# 0.65271f
C240 tanh_ota_0.V_ref gilbert_multiplier_current_1.V_x_n 0.03504f
C241 a_11555_17360# a_7766_18788# 0.03652f
C242 VDD a_13382_5774# 0.00179f
C243 voltage_reference_0.v_1_15 voltage_reference_0.v_1_25 0.00769f
C244 a_19458_10516# a_19458_8812# 0.0161f
C245 V_b tanh_ota_0.V_in_n 1.55496f
C246 voltage_reference_0.v_1_25 a_4405_12168# 0.02497f
C247 a_19914_9664# VDD 0.01292f
C248 a_2717_9730# tanh_ota_0.V_in_p 0.28218f
C249 voltage_reference_0.v_1_25 a_3598_8020# 0.72971f
C250 voltage_reference_0.v_1_25 a_7766_18788# 0
C251 a_13250_5878# a_13330_11368# 0.03052f
C252 VDD a_14558_20330# 0.09051f
C253 tanh_ota_0.V_ref V_out_perceptron 0
C254 a_3415_21020# a_2717_18262# 0.77452f
C255 a_9196_7474# voltage_reference_0.v_1_25 0
C256 a_3561_18262# a_2717_18262# 0.02724f
C257 a_13250_5878# a_14558_5878# 0.215f
C258 a_2717_15824# gilbert_multiplier_current_2.V_x_n 0.05207f
C259 a_21914_17004# a_19854_15770# 0.0161f
C260 a_13250_5878# a_11555_17360# 0.22118f
C261 tanh_ota_0.V_in_n a_7311_24128# 0.00281f
C262 a_14690_20226# voltage_reference_0.v_1_25 0.2801f
C263 a_11839_23276# V_out_perceptron 0.00247f
C264 tanh_ota_0.V_in_p a_10295_19296# 0.14065f
C265 tanh_ota_0.V_in_n a_3598_19300# 0.10508f
C266 tanh_ota_0.V_in_p voltage_reference_0.v_1_15 0
C267 a_7657_6436# voltage_reference_0.v_1_25 0.37895f
C268 tanh_ota_0.V_in_n a_3415_6100# 2.16944f
C269 a_14690_5774# a_14558_5878# 0.54051f
C270 V_w2 a_3415_6100# 0.65431f
C271 gilbert_multiplier_current_1.V_x_n a_3619_2602# 0
C272 a_13250_5878# voltage_reference_0.v_1_25 0.07725f
C273 tanh_ota_0.V_in_p a_7766_18788# 0.36364f
C274 a_13382_5774# a_14558_5878# 0.55708f
C275 tanh_ota_0.V_in_n a_4405_15824# 0
C276 tanh_ota_0.V_in_p a_9196_7474# 0
C277 a_2717_15824# voltage_reference_0.v_1_25 0.00402f
C278 tanh_ota_0.V_ref a_8559_11644# 0.98267f
C279 a_26642_8812# a_26642_10516# 0.0161f
C280 a_19914_9664# a_14558_5878# 0.0161f
C281 a_22199_13400# a_23777_13400# 0.99499f
C282 a_7311_22424# tanh_ota_0.V_in_n 0.01732f
C283 a_14558_5878# a_14558_20330# 0.02642f
C284 tanh_ota_0.V_ref tanh_ota_0.V_in_n 6.49808f
C285 a_11839_23276# a_13492_24053# 0.00156f
C286 tanh_ota_0.V_ref V_w2 3.92601f
C287 a_13330_9664# voltage_reference_0.v_1_15 0.0037f
C288 a_14690_20226# a_13382_20226# 0.41277f
C289 VDD a_14558_5878# 0.07822f
C290 a_3415_21020# a_3598_19300# 0
C291 voltage_reference_0.v_1_15 a_19458_8812# 0.01849f
C292 voltage_reference_0.v_1_25 a_14558_20330# 1.47413f
C293 a_3561_18262# a_3598_19300# 0.02791f
C294 a_26642_10516# voltage_reference_0.v_1_15 0.02041f
C295 a_2717_15824# tanh_ota_0.V_in_p 0.01311f
C296 a_13250_5878# a_13382_20226# 0.70429f
C297 a_8355_9194# voltage_reference_0.v_1_15 0
C298 VDD voltage_reference_0.v_1_25 6.79869f
C299 a_11839_24980# a_11839_23276# 0.0161f
C300 V_out_perceptron a_13330_16152# 0.00214f
C301 V_shift a_7766_18788# 0.00117f
C302 voltage_reference_0.v_1_15 a_19854_15770# 0.17122f
C303 tanh_ota_0.V_in_n a_3619_2602# 2.37444f
C304 a_13330_11368# a_14558_5878# 0.0088f
C305 a_8355_9194# a_9196_7474# 0
C306 V_w2 a_3619_2602# 0.71689f
C307 V_b voltage_reference_0.v_1_15 0.00333f
C308 a_13250_5878# a_13330_9664# 0.02924f
C309 a_3415_21020# tanh_ota_0.V_ref 0.7469f
C310 a_2717_9730# a_3561_9730# 0.02724f
C311 tanh_ota_0.V_ref a_3561_18262# 0.03093f
C312 a_2717_9730# a_3415_6100# 0.77529f
C313 a_9805_17650# a_11555_17360# 0.0059f
C314 a_8355_9194# a_7657_6436# 0.77621f
C315 a_8953_14522# V_out_perceptron 0
C316 a_13382_20226# a_14558_20330# 0.55712f
C317 VDD tanh_ota_0.V_in_p 0.11052f
C318 gilbert_multiplier_current_2.V_x_n voltage_reference_0.v_1_25 0.21462f
C319 a_13382_20226# VDD 0.00179f
C320 tanh_ota_0.V_in_n V_w1 1.32892f
C321 VDD a_3619_22696# 0.00546f
C322 I_x2 voltage_reference_0.v_1_25 0.20987f
C323 a_11555_17360# voltage_reference_0.v_1_25 0.0254f
C324 V_w2 VSS 6.11127f
C325 V_b VSS 7.21869f
C326 I_x2 VSS 2.66205f
C327 I_x1 VSS 2.67892f
C328 V_out_perceptron VSS 10.79114f
C329 V_shift VSS 3.6337f
C330 V_w1 VSS 5.70342f
C331 VDD VSS 0.14832p
C332 a_13492_1131# VSS 6.90433f
C333 a_14690_5774# VSS 1.43767f
C334 a_13382_5774# VSS 1.63765f
C335 a_9345_3998# VSS 1.3734f
C336 a_8501_6436# VSS 1.59945f
C337 a_7657_3998# VSS 1.37744f
C338 a_3619_2602# VSS 3.2564f
C339 a_3415_6100# VSS 2.66531f
C340 a_19914_7960# VSS 1.26323f
C341 a_26642_8812# VSS 1.52344f
C342 a_19458_8812# VSS 1.15657f
C343 a_9196_7474# VSS 2.86328f
C344 a_7657_6436# VSS 3.44657f
C345 a_3598_8020# VSS 3.30825f
C346 a_19914_9664# VSS 1.22088f
C347 a_13330_9664# VSS 1.66578f
C348 a_26642_10516# VSS 1.64278f
C349 a_19458_10516# VSS 1.25524f
C350 a_13330_11368# VSS 1.67099f
C351 voltage_reference_0.v_1_15 VSS 8.23164f
C352 a_23777_13400# VSS 4.54862f
C353 a_22199_13400# VSS 0.12817f
C354 a_8559_11644# VSS 2.47344f
C355 a_4405_12168# VSS 1.36843f
C356 a_3561_9730# VSS 1.59921f
C357 a_2717_9730# VSS 2.68403f
C358 a_2717_12168# VSS 1.42226f
C359 a_19458_12220# VSS 1.70911f
C360 a_14558_5878# VSS 9.00053f
C361 a_19467_13334# VSS 1.06213f
C362 a_8355_9194# VSS 3.16083f
C363 gilbert_multiplier_current_1.V_x_n VSS 5.12409f
C364 a_19854_15770# VSS 3.18764f
C365 a_26642_16152# VSS 1.72144f
C366 a_19458_15300# VSS 1.30485f
C367 a_13330_16152# VSS 1.80316f
C368 a_21914_17004# VSS 1.38373f
C369 a_19458_17004# VSS 1.29609f
C370 a_26642_17856# VSS 1.61377f
C371 a_13330_17856# VSS 1.65403f
C372 a_21914_18708# VSS 1.37777f
C373 a_14558_20330# VSS 9.0181f
C374 a_14690_20226# VSS 1.43767f
C375 a_13250_5878# VSS 17.2623f
C376 a_13382_20226# VSS 1.68973f
C377 a_9805_17650# VSS 1.58768f
C378 a_8953_14522# VSS 1.38267f
C379 a_10295_19296# VSS 0.59657f
C380 a_7766_18788# VSS 1.44377f
C381 a_4405_15824# VSS 1.36822f
C382 a_3561_18262# VSS 1.59946f
C383 a_2717_15824# VSS 1.43413f
C384 a_3598_19300# VSS 3.32452f
C385 a_2717_18262# VSS 2.6771f
C386 gilbert_multiplier_current_2.V_x_n VSS 5.12717f
C387 a_11555_17360# VSS 12.766f
C388 voltage_reference_0.v_1_25 VSS 21.9821f
C389 a_13492_24053# VSS 6.85617f
C390 a_7311_22424# VSS 1.21892f
C391 a_11839_23276# VSS 1.59488f
C392 a_3415_21020# VSS 2.66531f
C393 a_7311_24128# VSS 1.20881f
C394 tanh_ota_0.V_in_p VSS 18.4344f
C395 a_3619_22696# VSS 3.1909f
C396 tanh_ota_0.V_in_n VSS 12.9603f
C397 tanh_ota_0.V_ref VSS 46.3341f
C398 a_11839_24980# VSS 1.60478f
C399 VDD.t87 VSS 0.50774f
C400 VDD.t89 VSS 0.25328f
C401 VDD.n0 VSS 0.27842f
C402 VDD.n1 VSS 0.05668f
C403 VDD.t90 VSS 0.50774f
C404 VDD.t92 VSS 0.25328f
C405 VDD.n2 VSS 0.27842f
C406 VDD.n3 VSS 0.09421f
C407 VDD.n4 VSS 0.95473f
C408 VDD.n5 VSS 0.95112f
C409 VDD.t88 VSS 1.04652f
C410 VDD.t94 VSS 1.08851f
C411 VDD.t96 VSS 0.84769f
C412 VDD.t95 VSS 0.04217f
C413 VDD.t97 VSS 0.04217f
C414 VDD.n6 VSS 0.16395f
C415 VDD.t36 VSS 0.07355f
C416 VDD.n7 VSS 0.11069f
C417 VDD.t73 VSS 0.50774f
C418 VDD.t75 VSS 0.25328f
C419 VDD.n8 VSS 0.27842f
C420 VDD.t70 VSS 0.50774f
C421 VDD.t72 VSS 0.25328f
C422 VDD.n9 VSS 0.27842f
C423 VDD.n10 VSS 0.05655f
C424 VDD.n11 VSS 0.95112f
C425 VDD.n12 VSS 0.95473f
C426 VDD.t71 VSS 1.04652f
C427 VDD.t37 VSS 1.08851f
C428 VDD.t39 VSS 0.78506f
C429 VDD.n13 VSS 0.11661f
C430 VDD.n14 VSS 0.03758f
C431 VDD.t34 VSS 0.04217f
C432 VDD.t46 VSS 0.04217f
C433 VDD.n15 VSS 0.08435f
C434 VDD.n16 VSS 0.1121f
C435 VDD.t58 VSS 0.04217f
C436 VDD.t25 VSS 0.04217f
C437 VDD.n17 VSS 0.08435f
C438 VDD.n18 VSS 0.1121f
C439 VDD.n19 VSS 0.06153f
C440 VDD.t26 VSS 0.04217f
C441 VDD.t27 VSS 0.04217f
C442 VDD.n20 VSS 0.08435f
C443 VDD.n21 VSS 0.10593f
C444 VDD.n22 VSS 0.06739f
C445 VDD.n23 VSS 0.02821f
C446 VDD.t28 VSS 0.04217f
C447 VDD.t29 VSS 0.04217f
C448 VDD.n24 VSS 0.08435f
C449 VDD.n25 VSS 0.10593f
C450 VDD.n26 VSS 0.04344f
C451 VDD.t30 VSS 0.04217f
C452 VDD.t31 VSS 0.04217f
C453 VDD.n27 VSS 0.08435f
C454 VDD.n28 VSS 0.10593f
C455 VDD.n29 VSS 0.04344f
C456 VDD.n30 VSS 0.06739f
C457 VDD.t32 VSS 0.04217f
C458 VDD.t33 VSS 0.04217f
C459 VDD.n31 VSS 0.08435f
C460 VDD.n32 VSS 0.10593f
C461 VDD.n33 VSS 0.05217f
C462 VDD.n34 VSS 0.1064f
C463 VDD.n35 VSS 0.15193f
C464 VDD.n36 VSS 0
C465 VDD.n37 VSS 0.2431f
C466 VDD.n38 VSS 0.02703f
C467 VDD.n39 VSS 0.00808f
C468 VDD.n40 VSS 0
C469 VDD.n41 VSS 0.03383f
C470 VDD.n42 VSS 0.00816f
C471 VDD.n43 VSS 0.00831f
C472 VDD.n44 VSS 0.04179f
C473 VDD.t66 VSS 0.06943f
C474 VDD.n45 VSS 0.07779f
C475 VDD.t10 VSS 0.02109f
C476 VDD.t12 VSS 0.02109f
C477 VDD.n46 VSS 0.06832f
C478 VDD.t14 VSS 0.02109f
C479 VDD.t16 VSS 0.02109f
C480 VDD.n47 VSS 0.06832f
C481 VDD.t18 VSS 0.02109f
C482 VDD.t20 VSS 0.02109f
C483 VDD.n48 VSS 0.06832f
C484 VDD.n49 VSS 0.21273f
C485 VDD.n50 VSS 0.57015f
C486 VDD.n51 VSS 0.56652f
C487 VDD.t65 VSS 0.40527f
C488 VDD.t9 VSS 0.31832f
C489 VDD.t11 VSS 0.31832f
C490 VDD.t13 VSS 0.31832f
C491 VDD.t15 VSS 0.26137f
C492 VDD.t68 VSS 0.40527f
C493 VDD.t21 VSS 0.31832f
C494 VDD.t23 VSS 0.31832f
C495 VDD.t19 VSS 0.31832f
C496 VDD.t17 VSS 0.21611f
C497 VDD.n52 VSS 0.06857f
C498 VDD.n53 VSS 0.02959f
C499 VDD.t64 VSS 0.06424f
C500 VDD.n54 VSS 0.1046f
C501 VDD.t67 VSS 0.06424f
C502 VDD.n55 VSS 0.1046f
C503 VDD.n56 VSS 0.02959f
C504 VDD.t69 VSS 0.06943f
C505 VDD.n57 VSS 0.07779f
C506 VDD.t24 VSS 0.02109f
C507 VDD.t22 VSS 0.02109f
C508 VDD.n58 VSS 0.06832f
C509 VDD.n59 VSS 0.29139f
C510 VDD.n60 VSS 0.30043f
C511 VDD.n61 VSS 0.04416f
C512 VDD.n62 VSS 0.06769f
C513 VDD.n63 VSS 0.09161f
C514 VDD.n64 VSS 0.128f
C515 VDD.n65 VSS 0.15916f
C516 VDD.n66 VSS 0.12611f
C517 VDD.n67 VSS 0.06055f
C518 VDD.n68 VSS 0.22134f
C519 VDD.n69 VSS 0.29139f
C520 VDD.n70 VSS 0.20321f
C521 VDD.n71 VSS 0.12077f
C522 VDD.t45 VSS 0.04586f
C523 VDD.n72 VSS 0.36163f
C524 VDD.t47 VSS 0.04586f
C525 VDD.n73 VSS 0.23685f
C526 VDD.n74 VSS 0.03266f
C527 VDD.n75 VSS 0.01441f
C528 VDD.n76 VSS 1.14099f
C529 VDD.n77 VSS 0.78259f
C530 VDD.n78 VSS 0.01022f
C531 VDD.n79 VSS 0.26901f
C532 VDD.n80 VSS 0.30014f
C533 VDD.n81 VSS 0.04419f
C534 VDD.n82 VSS 0.12742f
C535 VDD.t38 VSS 0.04217f
C536 VDD.t40 VSS 0.04217f
C537 VDD.n83 VSS 0.16395f
C538 VDD.n84 VSS 0.12797f
C539 VDD.t42 VSS 0.04217f
C540 VDD.t44 VSS 0.04217f
C541 VDD.n85 VSS 0.16395f
C542 VDD.n86 VSS 0.14292f
C543 VDD.n87 VSS 0.02872f
C544 VDD.n88 VSS 0.18196f
C545 VDD.t74 VSS 1.04652f
C546 VDD.t43 VSS 1.08851f
C547 VDD.t41 VSS 0.84769f
C548 VDD.n89 VSS 0.54425f
C549 VDD.n90 VSS 0.17839f
C550 VDD.n91 VSS 0.09283f
C551 VDD.n92 VSS 0.05757f
C552 VDD.n93 VSS 0.26539f
C553 VDD.n94 VSS 0.23952f
C554 VDD.n95 VSS 0.04327f
C555 VDD.t61 VSS 0.1348f
C556 VDD.t63 VSS 0.06943f
C557 VDD.n96 VSS 0.07477f
C558 VDD.n97 VSS 0.07505f
C559 VDD.n98 VSS 0.02472f
C560 VDD.n99 VSS 0.09343f
C561 VDD.n100 VSS 0.09343f
C562 VDD.t79 VSS 0.1348f
C563 VDD.t80 VSS 0.10039f
C564 VDD.n101 VSS 0.12601f
C565 VDD.n102 VSS 0.03572f
C566 VDD.n103 VSS 0.24296f
C567 VDD.n104 VSS 0.07644f
C568 VDD.n105 VSS 0.07644f
C569 VDD.n106 VSS 1.34426f
C570 VDD.n107 VSS 0.06385f
C571 VDD.n108 VSS 0.06385f
C572 VDD.t5 VSS 0.02109f
C573 VDD.t6 VSS 0.02109f
C574 VDD.n109 VSS 0.06964f
C575 VDD.n110 VSS 0.07411f
C576 VDD.t7 VSS 0.02109f
C577 VDD.t8 VSS 0.02109f
C578 VDD.n111 VSS 0.06964f
C579 VDD.t85 VSS 0.25767f
C580 VDD.t86 VSS 0.25323f
C581 VDD.n112 VSS 0.18013f
C582 VDD.n113 VSS 0.04093f
C583 VDD.n114 VSS 1.5772f
C584 VDD.n115 VSS 0.06959f
C585 VDD.t35 VSS 1.27016f
C586 VDD.n116 VSS 0.03969f
C587 VDD.t93 VSS 0.15944f
C588 VDD.n117 VSS 0.29008f
C589 VDD.n118 VSS 0.10682f
C590 VDD.t83 VSS 0.25767f
C591 VDD.t84 VSS 0.25323f
C592 VDD.n119 VSS 0.18013f
C593 VDD.n120 VSS 0.03874f
C594 VDD.n121 VSS 0.04758f
C595 VDD.n122 VSS 0.00992f
C596 VDD.n123 VSS 0.04093f
C597 VDD.n124 VSS 0.10345f
C598 VDD.n125 VSS 0.1102f
C599 VDD.n126 VSS 1.33412f
C600 VDD.n127 VSS 0.11158f
C601 VDD.n128 VSS 0.03969f
C602 VDD.n129 VSS 0.00992f
C603 VDD.t81 VSS 0.1348f
C604 VDD.t82 VSS 0.10039f
C605 VDD.n130 VSS 0.12601f
C606 VDD.n131 VSS 0.03572f
C607 VDD.n132 VSS 0.03874f
C608 VDD.n133 VSS 0.04758f
C609 VDD.n134 VSS 0.07411f
C610 VDD.n135 VSS 0.0164f
C611 VDD.n136 VSS 0.0784f
C612 VDD.n137 VSS 0.77249f
C613 VDD.t4 VSS 0.70761f
C614 VDD.n138 VSS 0.74717f
C615 VDD.n140 VSS 1.07384f
C616 VDD.n141 VSS 0.44395f
C617 VDD.n142 VSS 0.24296f
C618 VDD.n143 VSS 0.02472f
C619 VDD.t76 VSS 0.1348f
C620 VDD.n144 VSS 0.07505f
C621 VDD.t78 VSS 0.06943f
C622 VDD.n145 VSS 0.07477f
C623 VDD.t1 VSS 0.02109f
C624 VDD.t3 VSS 0.02109f
C625 VDD.n146 VSS 0.06967f
C626 VDD.n147 VSS 0.07778f
C627 VDD.n148 VSS 0.04327f
C628 VDD.n149 VSS 0.07045f
C629 VDD.n150 VSS 0.03877f
C630 VDD.n151 VSS 0.50438f
C631 VDD.t77 VSS 0.44739f
C632 VDD.t0 VSS 0.30473f
C633 VDD.n152 VSS 0.20316f
C634 VDD.t2 VSS 0.30473f
C635 VDD.t62 VSS 0.44739f
C636 VDD.n153 VSS 0.50438f
C637 VDD.n154 VSS 0.03877f
C638 VDD.n155 VSS 0.07045f
C639 VDD.n156 VSS 0.23952f
C640 VDD.n157 VSS 0.17816f
C641 VDD.n158 VSS 0.11069f
C642 VDD.n159 VSS 0.14292f
C643 VDD.n160 VSS 0.11661f
C644 VDD.n161 VSS 0.05217f
C645 VDD.n162 VSS 0.02821f
C646 VDD.t60 VSS 0.04217f
C647 VDD.t48 VSS 0.04217f
C648 VDD.n163 VSS 0.08435f
C649 VDD.n164 VSS 0.1121f
C650 VDD.t49 VSS 0.04217f
C651 VDD.t50 VSS 0.04217f
C652 VDD.n165 VSS 0.08435f
C653 VDD.n166 VSS 0.10593f
C654 VDD.n167 VSS 0.06739f
C655 VDD.t57 VSS 0.04217f
C656 VDD.t59 VSS 0.04217f
C657 VDD.n168 VSS 0.08435f
C658 VDD.n169 VSS 0.1121f
C659 VDD.n170 VSS 0.06153f
C660 VDD.t55 VSS 0.04217f
C661 VDD.t56 VSS 0.04217f
C662 VDD.n171 VSS 0.08435f
C663 VDD.n172 VSS 0.10593f
C664 VDD.n173 VSS 0.06739f
C665 VDD.t53 VSS 0.04217f
C666 VDD.t54 VSS 0.04217f
C667 VDD.n174 VSS 0.08435f
C668 VDD.n175 VSS 0.10593f
C669 VDD.n176 VSS 0.04344f
C670 VDD.n177 VSS 0.04344f
C671 VDD.t51 VSS 0.04217f
C672 VDD.t52 VSS 0.04217f
C673 VDD.n178 VSS 0.08435f
C674 VDD.n179 VSS 0.10593f
C675 VDD.n180 VSS 0.03758f
C676 VDD.n181 VSS 0.1064f
C677 VDD.n182 VSS 0.15193f
C678 VDD.n183 VSS 0.05258f
C679 VDD.n184 VSS 0.12742f
C680 VDD.t99 VSS 0.04217f
C681 VDD.t101 VSS 0.04217f
C682 VDD.n185 VSS 0.16395f
C683 VDD.n186 VSS 0.12797f
C684 VDD.n187 VSS 0.02872f
C685 VDD.n188 VSS 0.18196f
C686 VDD.t91 VSS 1.04652f
C687 VDD.t100 VSS 1.08851f
C688 VDD.t98 VSS 0.78506f
C689 VDD.n189 VSS 0.54425f
C690 VDD.n190 VSS 0.17839f
C691 VDD.n191 VSS 0.04641f
C692 V_w1.t0 VSS 0.15095f
C693 V_w1.t1 VSS 0.15164f
C694 V_w1.n0 VSS 0.21844f
C695 V_w1.t4 VSS 0.15095f
C696 V_w1.t5 VSS 0.15164f
C697 V_w1.n1 VSS 0.2064f
C698 V_w1.n2 VSS 0.49086f
C699 V_w1.t8 VSS 0.17077f
C700 V_w1.n3 VSS 0.44401f
C701 V_w1.t12 VSS 0.17077f
C702 V_w1.n4 VSS 0.34532f
C703 V_w1.n5 VSS 0.62183f
C704 V_w1.t9 VSS 0.15164f
C705 V_w1.t10 VSS 0.15095f
C706 V_w1.n6 VSS 0.21849f
C707 V_w1.t13 VSS 0.15164f
C708 V_w1.t14 VSS 0.15095f
C709 V_w1.n7 VSS 0.2064f
C710 V_w1.n8 VSS 0.28362f
C711 V_w1.t2 VSS 0.15164f
C712 V_w1.t3 VSS 0.15095f
C713 V_w1.n9 VSS 0.21844f
C714 V_w1.t6 VSS 0.15164f
C715 V_w1.t7 VSS 0.15095f
C716 V_w1.n10 VSS 0.2064f
C717 V_w1.n11 VSS 0.49086f
C718 V_w1.t11 VSS 0.17077f
C719 V_w1.n12 VSS 0.44401f
C720 V_w1.t15 VSS 0.17077f
C721 V_w1.n13 VSS 0.33007f
C722 V_w1.n14 VSS 0.16875f
C723 V_shift.t0 VSS 0.1273f
C724 V_out_perceptron.t0 VSS 0.06206f
C725 V_out_perceptron.t1 VSS 0.06206f
C726 V_out_perceptron.n0 VSS 0.30042f
C727 V_out_perceptron.t3 VSS 0.06206f
C728 V_out_perceptron.t5 VSS 0.06206f
C729 V_out_perceptron.n1 VSS 0.32382f
C730 V_out_perceptron.t2 VSS 0.06206f
C731 V_out_perceptron.t4 VSS 0.06206f
C732 V_out_perceptron.n2 VSS 0.32387f
C733 V_out_perceptron.n3 VSS 0.23429f
C734 V_out_perceptron.n4 VSS 0.4813f
C735 V_out_perceptron.t6 VSS 0.13497f
C736 V_out_perceptron.n5 VSS 1.79896f
C737 V_out_perceptron.n6 VSS 0.32918f
C738 I_x1.t1 VSS 0.06805f
C739 I_x1.t0 VSS 0.06494f
C740 I_x1.n0 VSS 0.22889f
C741 I_x2.t1 VSS 0.06585f
C742 I_x2.t0 VSS 0.06284f
C743 I_x2.n0 VSS 0.22151f
C744 V_b.t9 VSS 0.15523f
C745 V_b.t10 VSS 0.15594f
C746 V_b.n0 VSS 0.22469f
C747 V_b.t13 VSS 0.15523f
C748 V_b.t14 VSS 0.15594f
C749 V_b.n1 VSS 0.21225f
C750 V_b.n2 VSS 0.29166f
C751 V_b.t0 VSS 0.15523f
C752 V_b.t1 VSS 0.15594f
C753 V_b.n3 VSS 0.22463f
C754 V_b.t4 VSS 0.15523f
C755 V_b.t5 VSS 0.15594f
C756 V_b.n4 VSS 0.21225f
C757 V_b.n5 VSS 0.50478f
C758 V_b.t8 VSS 0.17561f
C759 V_b.n6 VSS 0.45661f
C760 V_b.t12 VSS 0.17561f
C761 V_b.n7 VSS 0.33943f
C762 V_b.n8 VSS 0.17353f
C763 V_b.t2 VSS 0.15594f
C764 V_b.t3 VSS 0.15523f
C765 V_b.n9 VSS 0.22463f
C766 V_b.t6 VSS 0.15594f
C767 V_b.t7 VSS 0.15523f
C768 V_b.n10 VSS 0.21225f
C769 V_b.n11 VSS 0.50478f
C770 V_b.t11 VSS 0.17561f
C771 V_b.n12 VSS 0.45661f
C772 V_b.t15 VSS 0.17561f
C773 V_b.n13 VSS 0.23877f
C774 V_b.n14 VSS 1.56342f
C775 V_w2.t12 VSS 0.14781f
C776 V_w2.t13 VSS 0.14849f
C777 V_w2.n0 VSS 0.2139f
C778 V_w2.t8 VSS 0.14781f
C779 V_w2.t9 VSS 0.14849f
C780 V_w2.n1 VSS 0.20211f
C781 V_w2.n2 VSS 0.48066f
C782 V_w2.t4 VSS 0.16722f
C783 V_w2.n3 VSS 0.43479f
C784 V_w2.t0 VSS 0.16722f
C785 V_w2.n4 VSS 0.34471f
C786 V_w2.t5 VSS 0.14849f
C787 V_w2.t6 VSS 0.14781f
C788 V_w2.n5 VSS 0.21395f
C789 V_w2.t1 VSS 0.14849f
C790 V_w2.t2 VSS 0.14781f
C791 V_w2.n6 VSS 0.20211f
C792 V_w2.n7 VSS 0.27772f
C793 V_w2.t14 VSS 0.14849f
C794 V_w2.t15 VSS 0.14781f
C795 V_w2.n8 VSS 0.2139f
C796 V_w2.t10 VSS 0.14849f
C797 V_w2.t11 VSS 0.14781f
C798 V_w2.n9 VSS 0.20211f
C799 V_w2.n10 VSS 0.48066f
C800 V_w2.t7 VSS 0.16722f
C801 V_w2.n11 VSS 0.43479f
C802 V_w2.t3 VSS 0.16722f
C803 V_w2.n12 VSS 0.22736f
C804 V_w2.n13 VSS 0.70823f
C805 V_w2.n14 VSS 0.1289f
.ends perceptron_core_pex_rc
