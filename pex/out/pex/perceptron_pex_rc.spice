* perceptron_pex_rc — Magic RC extraction of perceptron (gds/perceptron.gds)
* generated by pex/pex.tcl, see pex/out/env.txt for provenance
* ports (schematic order): VDD V_shift V_w1 I_x1 V_out_perceptron V_b I_x2 V_w2 VSS
* NGSPICE file created from perceptron.ext - technology: gf180mcuD

.subckt perceptron_pex_rc VDD V_shift V_w1 I_x1 V_out_perceptron V_b I_x2 V_w2 VSS
X0 VSS.t55 VSS.t53 VSS.t55 VSS.t54 nfet_03v3 ad=0.915p pd=4.22u as=0 ps=0 w=1.5u l=0.5u
D0 VSS.t302 I_x1_core diode_nd2ps_06v0 pj=40u area=99.99999p
D1 VSS.t312 V_w2_core diode_nd2ps_06v0 pj=40u area=99.99999p
X1 a_49135_56824# perceptron_core_0.tanh_ota_0.V_ref perceptron_core_0.tanh_ota_0.V_in_n VSS.t93 nfet_03v3 ad=0.65p pd=3.02u as=0.65p ps=3.02u w=2.5u l=0.5u
X2 a_50871_64476# a_52131_62540# VSS.t238 VSS.t237 nfet_03v3 ad=0.39p pd=2.02u as=0.39p ps=2.02u w=1.5u l=0.5u
X3 a_49135_56824# perceptron_core_0.voltage_reference_0.v_1_15 a_49772_52654# VSS.t10 nfet_03v3 ad=1.3p pd=5.52u as=1.3p ps=5.52u w=5u l=0.5u
X4 a_49135_56824# V_b_core perceptron_core_0.tanh_ota_0.V_in_p VSS.t93 nfet_03v3 ad=0.65p pd=3.02u as=0.65p ps=3.02u w=2.5u l=0.5u
X5 perceptron_core_0.gilbert_multiplier_current_2.V_x_n perceptron_core_0.voltage_reference_0.v_1_25 I_x1_core VSS.t6 nfet_03v3 ad=0.65p pd=3.02u as=1.525p ps=6.22u w=2.5u l=0.5u
X6 a_62490_62184# a_67218_61332# VSS.t271 ppolyf_u_1k r_width=3u r_length=23u
X7 a_49135_56824# VSS.t116 VSS.t117 VSS.t10 nfet_03v3 ad=1.3p pd=5.52u as=3.05p ps=11.22u w=5u l=0.5u
X8 a_49135_56824# perceptron_core_0.tanh_ota_0.V_ref perceptron_core_0.tanh_ota_0.V_in_n VSS.t93 nfet_03v3 ad=0.65p pd=3.02u as=0.65p ps=3.02u w=2.5u l=0.5u
X9 a_53906_61332# a_60034_62184# VSS.t289 ppolyf_u_1k r_width=3u r_length=30u
D2 VSS.t302 I_x1_core diode_nd2ps_06v0 pj=40u area=99.99999p
X10 perceptron_core_0.voltage_reference_0.v_1_25 a_54068_69233# VDD.t10 VSS.t268 nfet_03v3 ad=2.6p pd=10.52u as=2.6p ps=10.52u w=10u l=1u
X11 perceptron_core_0.tanh_ota_0.V_in_p V_b_core a_49135_56824# VSS.t90 nfet_03v3 ad=0.65p pd=3.02u as=0.65p ps=3.02u w=2.5u l=0.5u
D3 I_x2_core VDD.t123 diode_pd2nw_06v0 pj=40u area=99.99999p
X12 a_55266_65406# a_55134_65510# a_53958_65406# VSS.t195 nfet_03v3 ad=1.3p pd=5.52u as=1.3p ps=5.52u w=5u l=2u
X13 perceptron_core_0.tanh_ota_0.V_in_n perceptron_core_0.tanh_ota_0.V_ref a_49135_56824# VSS.t90 nfet_03v3 ad=0.65p pd=3.02u as=0.65p ps=3.02u w=2.5u l=0.5u
X14 VDD.t28 VDD.t26 a_55266_65406# VDD.t27 pfet_03v3 ad=6.5p pd=21.3u as=2.6p ps=10.52u w=10u l=2u
X15 VSS.t250 a_52131_62540# a_52131_62540# VSS.t249 nfet_03v3 ad=0.39p pd=2.02u as=0.39p ps=2.02u w=1.5u l=0.5u
D4 VSS.t306 V_shift_core diode_nd2ps_06v0 pj=40u area=99.99999p
D5 V_shift_core VDD.t111 diode_pd2nw_06v0 pj=40u area=99.99999p
X16 VDD.t9 a_54068_69233# perceptron_core_0.voltage_reference_0.v_1_25 VSS.t267 nfet_03v3 ad=2.6p pd=10.52u as=2.6p ps=10.52u w=10u l=1u
X17 VSS.t183 perceptron_core_0.tanh_ota_0.V_ref a_48233_51616# VSS.t134 nfet_03v3 ad=1.04p pd=4.52u as=1.04p ps=4.52u w=4u l=1u
X18 VDD.t84 a_54068_46311# perceptron_core_0.tanh_ota_0.V_ref VSS.t295 nfet_03v3 ad=2.6p pd=10.52u as=2.6p ps=10.52u w=10u l=1u
X19 VDD.t105 a_48342_63968# a_48342_63968# VDD.t104 pfet_03v3 ad=1.3p pd=5.52u as=1.3p ps=5.52u w=5u l=0.5u
X20 a_53906_56548# a_60034_55696# VSS.t255 ppolyf_u_1k r_width=3u r_length=30u
X21 a_54068_69233# perceptron_core_0.voltage_reference_0.v_1_25 a_53958_65406# VSS.t8 nfet_03v3 ad=1.3p pd=5.52u as=1.3p ps=5.52u w=5u l=2u
X22 VSS.t23 VSS.t21 perceptron_core_0.tanh_ota_0.V_in_n VSS.t22 nfet_03v3 ad=1.525p pd=6.22u as=0.65p ps=3.02u w=2.5u l=0.5u
D6 V_w1_core VDD.t91 diode_pd2nw_06v0 pj=40u area=99.99999p
X23 perceptron_core_0.tanh_ota_0.V_in_p V_w2_core a_43991_51280# VSS.t150 nfet_03v3 ad=0.65p pd=3.02u as=0.65p ps=3.02u w=2.5u l=0.5u
X24 VSS.t106 VSS.t104 a_64353_58580# VSS.t105 nfet_03v3 ad=3.05p pd=11.22u as=1.3p ps=5.52u w=5u l=1u
X25 VDD.t19 a_55266_65406# a_54068_69233# VDD.t18 pfet_03v3 ad=2.6p pd=10.52u as=2.6p ps=10.52u w=10u l=2u
X26 VSS.t31 VSS.t29 VDD.t112 VSS.t30 nfet_03v3 ad=6.1p pd=21.22u as=2.6p ps=10.52u w=10u l=1u
X27 a_44195_67876# perceptron_core_0.tanh_ota_0.V_ref perceptron_core_0.tanh_ota_0.V_in_p VSS.t4 nfet_03v3 ad=0.65p pd=3.02u as=0.65p ps=3.02u w=2.5u l=0.5u
X28 perceptron_core_0.tanh_ota_0.V_in_n V_w2_core a_44195_47782# VSS.t128 nfet_03v3 ad=0.65p pd=3.02u as=0.65p ps=3.02u w=2.5u l=0.5u
X29 perceptron_core_0.tanh_ota_0.V_in_n perceptron_core_0.tanh_ota_0.V_ref a_43991_66200# VSS.t172 nfet_03v3 ad=0.65p pd=3.02u as=0.65p ps=3.02u w=2.5u l=0.5u
X30 perceptron_core_0.tanh_ota_0.V_in_p perceptron_core_0.tanh_ota_0.V_ref a_44195_47782# VSS.t128 nfet_03v3 ad=0.65p pd=3.02u as=0.65p ps=3.02u w=2.5u l=0.5u
X31 a_55266_65406# VSS.t79 VSS.t80 VSS.t75 nfet_03v3 ad=1.3p pd=5.52u as=3.05p ps=11.22u w=5u l=2u
X32 VDD.t68 VSS.t42 VSS.t44 VSS.t43 nfet_03v3 ad=2.6p pd=10.52u as=6.1p ps=21.22u w=10u l=1u
X33 perceptron_core_0.tanh_ota_0.V_in_n perceptron_core_0.tanh_ota_0.V_ref a_43991_51280# VSS.t125 nfet_03v3 ad=0.65p pd=3.02u as=0.65p ps=3.02u w=2.5u l=0.5u
X34 a_53958_65406# a_53826_51058# VSS.t196 VSS.t195 nfet_03v3 ad=0.65p pd=3.02u as=0.65p ps=3.02u w=2.5u l=2u
X35 VSS.t115 VSS.t114 a_48931_54374# VSS.t10 nfet_03v3 ad=3.05p pd=11.22u as=1.3p ps=5.52u w=5u l=0.5u
X36 a_55134_51058# a_67218_55696# VSS.t12 ppolyf_u_1k r_width=3u r_length=33u
X37 perceptron_core_0.tanh_ota_0.V_in_p V_w2_core a_43991_51280# VSS.t125 nfet_03v3 ad=0.65p pd=3.02u as=0.65p ps=3.02u w=2.5u l=0.5u
X38 V_w2.t0 V_w2_core VDD.t1 ppolyf_u r_width=40u r_length=10u
X39 VSS.t202 a_53826_51058# a_53826_51058# VSS.t201 nfet_03v3 ad=1.3p pd=5.52u as=1.3p ps=5.52u w=5u l=1u
X40 a_48233_51616# perceptron_core_0.voltage_reference_0.v_1_25 a_48931_54374# VSS.t10 nfet_03v3 ad=1.3p pd=5.52u as=1.3p ps=5.52u w=5u l=0.5u
X41 VSS.t138 VSS.t136 perceptron_core_0.tanh_ota_0.V_in_p VSS.t137 nfet_03v3 ad=1.525p pd=6.22u as=0.65p ps=3.02u w=2.5u l=0.5u
X42 VSS.t182 perceptron_core_0.tanh_ota_0.V_ref a_43293_54910# VSS.t108 nfet_03v3 ad=1.04p pd=4.52u as=1.04p ps=4.52u w=4u l=1u
X43 a_49135_56824# V_b_core perceptron_core_0.tanh_ota_0.V_in_p VSS.t90 nfet_03v3 ad=0.65p pd=3.02u as=0.65p ps=3.02u w=2.5u l=0.5u
X44 V_shift.t0 V_shift_core VDD.t110 ppolyf_u r_width=40u r_length=10u
X45 perceptron_core_0.tanh_ota_0.V_in_n VSS.t19 VSS.t20 VSS.t17 nfet_03v3 ad=0.65p pd=3.02u as=1.525p ps=6.22u w=2.5u l=0.5u
X46 a_43991_51280# V_w2_core perceptron_core_0.tanh_ota_0.V_in_p VSS.t150 nfet_03v3 ad=0.65p pd=3.02u as=0.65p ps=3.02u w=2.5u l=0.5u
X47 perceptron_core_0.tanh_ota_0.V_ref a_54068_46311# VDD.t87 VSS.t298 nfet_03v3 ad=2.6p pd=10.52u as=2.6p ps=10.52u w=10u l=1u
X48 a_53958_65406# a_53826_51058# VSS.t198 VSS.t8 nfet_03v3 ad=0.65p pd=3.02u as=0.65p ps=3.02u w=2.5u l=2u
X49 a_44195_47782# V_w2_core perceptron_core_0.tanh_ota_0.V_in_n VSS.t137 nfet_03v3 ad=0.65p pd=3.02u as=0.65p ps=3.02u w=2.5u l=0.5u
X50 a_62775_58580# a_60430_60950# a_64353_58580# VDD.t2 pfet_03v3 ad=2.6p pd=10.52u as=2.6p ps=10.52u w=10u l=1u
X51 a_49135_56824# perceptron_core_0.tanh_ota_0.V_ref perceptron_core_0.tanh_ota_0.V_in_n VSS.t90 nfet_03v3 ad=0.65p pd=3.02u as=0.65p ps=3.02u w=2.5u l=0.5u
X52 a_50381_62830# a_49529_59702# VSS.t260 ppolyf_u_1k r_width=3u r_length=15u
X53 VSS.t224 a_52131_62540# a_52131_62540# VSS.t223 nfet_03v3 ad=0.39p pd=2.02u as=0.39p ps=2.02u w=1.5u l=0.5u
X54 a_48342_63968# VSS.t68 VSS.t70 VSS.t69 nfet_03v3 ad=1.3p pd=5.52u as=3.05p ps=11.22u w=5u l=0.5u
X55 perceptron_core_0.tanh_ota_0.V_in_p perceptron_core_0.tanh_ota_0.V_ref a_48931_54374# VSS.t100 nfet_03v3 ad=0.65p pd=3.02u as=0.65p ps=3.02u w=2.5u l=0.5u
X56 a_49135_56824# V_b_core perceptron_core_0.tanh_ota_0.V_in_p VSS.t90 nfet_03v3 ad=0.65p pd=3.02u as=0.65p ps=3.02u w=2.5u l=0.5u
X57 a_43991_66200# perceptron_core_0.tanh_ota_0.V_ref perceptron_core_0.tanh_ota_0.V_in_n VSS.t171 nfet_03v3 ad=0.65p pd=3.02u as=0.65p ps=3.02u w=2.5u l=0.5u
X58 a_43991_51280# perceptron_core_0.gilbert_multiplier_current_1.V_x_n a_43293_54910# VSS.t11 nfet_03v3 ad=1.3p pd=5.52u as=1.3p ps=5.52u w=5u l=0.5u
X59 perceptron_core_0.tanh_ota_0.V_in_n V_b_core a_48931_54374# VSS.t100 nfet_03v3 ad=0.65p pd=3.02u as=0.65p ps=3.02u w=2.5u l=0.5u
X60 a_53958_65406# VSS.t74 VSS.t76 VSS.t75 nfet_03v3 ad=0.65p pd=3.02u as=1.525p ps=6.22u w=2.5u l=2u
X61 VSS.t240 a_52131_62540# a_52131_62540# VSS.t239 nfet_03v3 ad=0.39p pd=2.02u as=0.39p ps=2.02u w=1.5u l=0.5u
D7 VSS.t308 V_out_perceptron_core diode_nd2ps_06v0 pj=40u area=99.99999p
X62 VSS.t277 a_64353_58580# perceptron_core_0.voltage_reference_0.v_1_15 VSS.t276 nfet_03v3 ad=1.3p pd=5.52u as=1.3p ps=5.52u w=5u l=1u
X63 a_62775_58580# a_60034_57400# VDD.t77 VDD.t48 pfet_03v3 ad=1.3p pd=5.52u as=1.3p ps=5.52u w=5u l=1u
X64 VSS.t158 VSS.t157 a_55266_50954# VSS.t131 nfet_03v3 ad=3.05p pd=11.22u as=1.3p ps=5.52u w=5u l=2u
D8 VSS.t302 I_x1_core diode_nd2ps_06v0 pj=40u area=99.99999p
D9 V_w1_core VDD.t91 diode_pd2nw_06v0 pj=40u area=99.99999p
X65 perceptron_core_0.tanh_ota_0.V_in_p VSS.t145 VSS.t146 VSS.t137 nfet_03v3 ad=0.65p pd=3.02u as=1.525p ps=6.22u w=2.5u l=0.5u
X66 a_60034_57400# a_60034_57400# VDD.t73 VDD.t72 pfet_03v3 ad=1.3p pd=5.52u as=1.3p ps=5.52u w=5u l=1u
X67 a_55134_65510# a_60430_60950# VSS.t288 ppolyf_u_1k r_width=3u r_length=10u
X68 a_53958_50954# perceptron_core_0.tanh_ota_0.V_ref a_54068_46311# VSS.t190 nfet_03v3 ad=1.3p pd=5.52u as=1.3p ps=5.52u w=5u l=2u
X69 VSS.t179 perceptron_core_0.tanh_ota_0.V_ref a_43293_63442# VSS.t178 nfet_03v3 ad=1.04p pd=4.52u as=1.04p ps=4.52u w=4u l=1u
D10 V_b_core VDD.t14 diode_pd2nw_06v0 pj=40u area=99.99999p
X70 VDD.t80 a_54068_46311# perceptron_core_0.tanh_ota_0.V_ref VSS.t291 nfet_03v3 ad=2.6p pd=10.52u as=2.6p ps=10.52u w=10u l=1u
X71 a_62490_63888# a_67218_63036# VSS.t271 ppolyf_u_1k r_width=3u r_length=23u
D11 VSS.t311 V_out_perceptron_core diode_nd2ps_06v0 pj=40u area=99.99999p
X72 a_53958_50954# a_55134_51058# a_55266_50954# VSS.t207 nfet_03v3 ad=1.3p pd=5.52u as=1.3p ps=5.52u w=5u l=2u
X73 perceptron_core_0.tanh_ota_0.V_in_n V_b_core a_48931_54374# VSS.t27 nfet_03v3 ad=0.65p pd=3.02u as=0.65p ps=3.02u w=2.5u l=0.5u
X74 a_53906_63036# VDD.t79 VSS.t290 ppolyf_u_1k r_width=3u r_length=30u
X75 a_48931_54374# perceptron_core_0.tanh_ota_0.V_ref perceptron_core_0.tanh_ota_0.V_in_p VSS.t100 nfet_03v3 ad=0.65p pd=3.02u as=0.65p ps=3.02u w=2.5u l=0.5u
X76 a_53958_65406# a_55134_65510# a_55266_65406# VSS.t199 nfet_03v3 ad=1.3p pd=5.52u as=1.3p ps=5.52u w=5u l=2u
X77 VSS.t132 VSS.t130 a_53958_50954# VSS.t131 nfet_03v3 ad=1.525p pd=6.22u as=0.65p ps=3.02u w=2.5u l=2u
D12 V_w2_core VDD.t116 diode_pd2nw_06v0 pj=40u area=99.99999p
X78 perceptron_core_0.tanh_ota_0.V_in_p perceptron_core_0.tanh_ota_0.V_ref a_48931_54374# VSS.t27 nfet_03v3 ad=0.65p pd=3.02u as=0.65p ps=3.02u w=2.5u l=0.5u
X79 perceptron_core_0.tanh_ota_0.V_in_n V_w2_core a_44195_47782# VSS.t128 nfet_03v3 ad=0.65p pd=3.02u as=0.65p ps=3.02u w=2.5u l=0.5u
X80 a_48931_54374# V_b_core perceptron_core_0.tanh_ota_0.V_in_n VSS.t100 nfet_03v3 ad=0.65p pd=3.02u as=0.65p ps=3.02u w=2.5u l=0.5u
X81 VSS.t212 a_52131_62540# a_52131_62540# VSS.t211 nfet_03v3 ad=0.39p pd=2.02u as=0.39p ps=2.02u w=1.5u l=0.5u
X82 a_48931_54374# perceptron_core_0.tanh_ota_0.V_ref perceptron_core_0.tanh_ota_0.V_in_p VSS.t100 nfet_03v3 ad=0.65p pd=3.02u as=0.65p ps=3.02u w=2.5u l=0.5u
X83 VDD.t7 a_54068_69233# perceptron_core_0.voltage_reference_0.v_1_25 VSS.t265 nfet_03v3 ad=2.6p pd=10.52u as=2.6p ps=10.52u w=10u l=1u
D13 V_b_core VDD.t17 diode_pd2nw_06v0 pj=40u area=99.99999p
X84 perceptron_core_0.tanh_ota_0.V_in_n perceptron_core_0.tanh_ota_0.V_ref a_43991_51280# VSS.t125 nfet_03v3 ad=0.65p pd=3.02u as=0.65p ps=3.02u w=2.5u l=0.5u
X85 VSS.t205 a_53826_51058# a_53958_50954# VSS.t190 nfet_03v3 ad=0.65p pd=3.02u as=0.65p ps=3.02u w=2.5u l=2u
X86 perceptron_core_0.tanh_ota_0.V_ref VSS.t287 VSS.t286 ppolyf_u_1k r_width=3u r_length=20u
D14 VSS.t284 V_b_core diode_nd2ps_06v0 pj=40u area=99.99999p
X87 a_52131_62540# a_52131_62540# VSS.t232 VSS.t69 nfet_03v3 ad=0.39p pd=2.02u as=0.39p ps=2.02u w=1.5u l=0.5u
X88 a_55266_65406# a_55266_65406# VDD.t21 VDD.t20 pfet_03v3 ad=2.6p pd=10.52u as=2.6p ps=10.52u w=10u l=2u
X89 perceptron_core_0.tanh_ota_0.V_in_p perceptron_core_0.tanh_ota_0.V_ref a_44195_67876# VSS.t170 nfet_03v3 ad=0.65p pd=3.02u as=0.65p ps=3.02u w=2.5u l=0.5u
X90 VSS.t208 a_53826_51058# a_53958_50954# VSS.t207 nfet_03v3 ad=0.65p pd=3.02u as=0.65p ps=3.02u w=2.5u l=2u
X91 perceptron_core_0.tanh_ota_0.V_ref a_54068_46311# VDD.t89 VSS.t300 nfet_03v3 ad=2.6p pd=10.52u as=2.6p ps=10.52u w=10u l=1u
X92 VSS.t200 a_53826_51058# a_53958_65406# VSS.t199 nfet_03v3 ad=0.65p pd=3.02u as=0.65p ps=3.02u w=2.5u l=2u
X93 VDD.t53 VDD.t52 a_64353_58580# VDD.t2 pfet_03v3 ad=6.5p pd=21.3u as=2.6p ps=10.52u w=10u l=1u
X94 a_44195_47782# V_w2_core perceptron_core_0.tanh_ota_0.V_in_n VSS.t128 nfet_03v3 ad=0.65p pd=3.02u as=0.65p ps=3.02u w=2.5u l=0.5u
X95 a_54068_69233# a_55266_65406# VDD.t23 VDD.t22 pfet_03v3 ad=2.6p pd=10.52u as=2.6p ps=10.52u w=10u l=2u
D15 VSS.t282 V_b_core diode_nd2ps_06v0 pj=40u area=99.99999p
X96 a_48931_54374# V_b_core perceptron_core_0.tanh_ota_0.V_in_n VSS.t27 nfet_03v3 ad=0.65p pd=3.02u as=0.65p ps=3.02u w=2.5u l=0.5u
X97 VSS.t58 VSS.t56 VSS.t58 VSS.t57 nfet_03v3 ad=0.39p pd=2.02u as=0 ps=0 w=1.5u l=0.5u
X98 a_43991_51280# perceptron_core_0.tanh_ota_0.V_ref perceptron_core_0.tanh_ota_0.V_in_n VSS.t125 nfet_03v3 ad=0.65p pd=3.02u as=0.65p ps=3.02u w=2.5u l=0.5u
X99 a_44174_53200# perceptron_core_0.tanh_ota_0.V_ref VSS.t186 VSS.t108 nfet_03v3 ad=1.04p pd=4.52u as=1.04p ps=4.52u w=4u l=1u
X100 a_48931_54374# perceptron_core_0.tanh_ota_0.V_ref perceptron_core_0.tanh_ota_0.V_in_p VSS.t27 nfet_03v3 ad=0.65p pd=3.02u as=0.65p ps=3.02u w=2.5u l=0.5u
X101 a_55266_65406# VDD.t29 VDD.t31 VDD.t30 pfet_03v3 ad=2.6p pd=10.52u as=6.5p ps=21.3u w=10u l=2u
X102 VDD.t107 a_48342_63968# V_out_perceptron_core VDD.t106 pfet_03v3 ad=1.3p pd=5.52u as=1.3p ps=5.52u w=5u l=0.5u
X103 a_62775_58580# VDD.t50 VDD.t51 VDD.t48 pfet_03v3 ad=1.3p pd=5.52u as=3.25p ps=11.3u w=5u l=1u
X104 a_55266_50954# a_55134_51058# a_53958_50954# VSS.t203 nfet_03v3 ad=1.3p pd=5.52u as=1.3p ps=5.52u w=5u l=2u
X105 a_48931_54374# V_b_core perceptron_core_0.tanh_ota_0.V_in_n VSS.t27 nfet_03v3 ad=0.65p pd=3.02u as=0.65p ps=3.02u w=2.5u l=0.5u
X106 perceptron_core_0.tanh_ota_0.V_in_n V_w2_core a_44195_47782# VSS.t137 nfet_03v3 ad=0.65p pd=3.02u as=0.65p ps=3.02u w=2.5u l=0.5u
X107 a_55134_65510# a_60043_58514# VSS.t285 ppolyf_u_1k r_width=3u r_length=20u
X108 a_44195_67876# perceptron_core_0.tanh_ota_0.V_ref perceptron_core_0.tanh_ota_0.V_in_p VSS.t173 nfet_03v3 ad=0.65p pd=3.02u as=0.65p ps=3.02u w=2.5u l=0.5u
X109 VDD.t3 a_54068_69233# perceptron_core_0.voltage_reference_0.v_1_25 VSS.t261 nfet_03v3 ad=2.6p pd=10.52u as=2.6p ps=10.52u w=10u l=1u
X110 a_60430_60950# a_67218_61332# VSS.t271 ppolyf_u_1k r_width=3u r_length=23u
X111 VSS.t47 VSS.t45 a_43991_66200# VSS.t46 nfet_03v3 ad=3.05p pd=11.22u as=1.3p ps=5.52u w=5u l=0.5u
X112 a_44195_67876# V_w1_core perceptron_core_0.tanh_ota_0.V_in_n VSS.t46 nfet_03v3 ad=0.65p pd=3.02u as=0.65p ps=3.02u w=2.5u l=0.5u
X113 VSS.t184 perceptron_core_0.tanh_ota_0.V_ref a_44174_53200# VSS.t108 nfet_03v3 ad=1.04p pd=4.52u as=1.04p ps=4.52u w=4u l=1u
X114 a_53906_61332# a_60034_60480# VSS.t307 ppolyf_u_1k r_width=3u r_length=30u
X115 a_54068_46311# perceptron_core_0.tanh_ota_0.V_ref a_53958_50954# VSS.t191 nfet_03v3 ad=1.3p pd=5.52u as=1.3p ps=5.52u w=5u l=2u
X116 VDD.t11 a_54068_69233# perceptron_core_0.voltage_reference_0.v_1_25 VSS.t269 nfet_03v3 ad=2.6p pd=10.52u as=2.6p ps=10.52u w=10u l=1u
X117 a_43991_66200# V_w1_core perceptron_core_0.tanh_ota_0.V_in_p VSS.t173 nfet_03v3 ad=0.65p pd=3.02u as=0.65p ps=3.02u w=2.5u l=0.5u
X118 a_52131_62540# a_52131_62540# VSS.t252 VSS.t251 nfet_03v3 ad=0.39p pd=2.02u as=0.39p ps=2.02u w=1.5u l=0.5u
D16 VSS.t310 V_out_perceptron_core diode_nd2ps_06v0 pj=40u area=99.99999p
D17 V_out_perceptron_core VDD.t114 diode_pd2nw_06v0 pj=40u area=99.99999p
D18 VSS.t309 V_out_perceptron_core diode_nd2ps_06v0 pj=40u area=99.99999p
X119 VSS.t15 VSS.t13 a_53826_51058# VSS.t14 nfet_03v3 ad=3.05p pd=11.22u as=1.3p ps=5.52u w=5u l=1u
X120 a_48342_63968# a_48342_63968# VDD.t99 VDD.t98 pfet_03v3 ad=1.3p pd=5.52u as=1.3p ps=5.52u w=5u l=0.5u
X121 a_43991_66200# perceptron_core_0.tanh_ota_0.V_ref perceptron_core_0.tanh_ota_0.V_in_n VSS.t46 nfet_03v3 ad=0.65p pd=3.02u as=0.65p ps=3.02u w=2.5u l=0.5u
X122 a_52131_62540# a_52131_62540# VSS.t226 VSS.t225 nfet_03v3 ad=0.39p pd=2.02u as=0.39p ps=2.02u w=1.5u l=0.5u
X123 a_55266_50954# VSS.t159 VSS.t160 VSS.t155 nfet_03v3 ad=1.3p pd=5.52u as=3.05p ps=11.22u w=5u l=2u
X124 perceptron_core_0.tanh_ota_0.V_ref a_54068_46311# VDD.t85 VSS.t296 nfet_03v3 ad=2.6p pd=10.52u as=2.6p ps=10.52u w=10u l=1u
X125 a_62775_58580# perceptron_core_0.voltage_reference_0.v_1_15 perceptron_core_0.voltage_reference_0.v_1_15 VDD.t2 pfet_03v3 ad=2.6p pd=10.52u as=2.6p ps=10.52u w=10u l=1u
X126 a_44195_47782# perceptron_core_0.voltage_reference_0.v_1_25 a_44174_53200# VSS.t11 nfet_03v3 ad=1.3p pd=5.52u as=1.3p ps=5.52u w=5u l=0.5u
X127 a_49772_52654# perceptron_core_0.tanh_ota_0.V_ref VSS.t187 VSS.t134 nfet_03v3 ad=1.04p pd=4.52u as=1.04p ps=4.52u w=4u l=1u
X128 perceptron_core_0.gilbert_multiplier_current_2.V_x_n perceptron_core_0.voltage_reference_0.v_1_25 VSS.t304 ppolyf_u_1k r_width=3u r_length=8.1u
X129 a_53958_50954# a_53826_51058# VSS.t204 VSS.t203 nfet_03v3 ad=0.65p pd=3.02u as=0.65p ps=3.02u w=2.5u l=2u
X130 a_44195_47782# VSS.t139 VSS.t140 VSS.t11 nfet_03v3 ad=1.3p pd=5.52u as=3.05p ps=11.22u w=5u l=0.5u
X131 VDD.t40 VDD.t38 a_55266_50954# VDD.t39 pfet_03v3 ad=6.5p pd=21.3u as=2.6p ps=10.52u w=10u l=2u
D19 VSS.t318 I_x2_core diode_nd2ps_06v0 pj=40u area=99.99999p
X132 a_44174_64480# perceptron_core_0.tanh_ota_0.V_ref VSS.t181 VSS.t180 nfet_03v3 ad=1.04p pd=4.52u as=1.04p ps=4.52u w=4u l=1u
D20 VSS.t301 V_w1_core diode_nd2ps_06v0 pj=40u area=99.99999p
X133 a_53958_50954# a_53826_51058# VSS.t206 VSS.t191 nfet_03v3 ad=0.65p pd=3.02u as=0.65p ps=3.02u w=2.5u l=2u
X134 a_62775_58580# a_60034_57400# VDD.t71 VDD.t48 pfet_03v3 ad=1.3p pd=5.52u as=1.3p ps=5.52u w=5u l=1u
X135 VSS.t258 a_60034_53992# VSS.t257 ppolyf_u_1k r_width=3u r_length=30u
X136 VDD.t62 a_55266_50954# a_54068_46311# VDD.t61 pfet_03v3 ad=2.6p pd=10.52u as=2.6p ps=10.52u w=10u l=2u
D21 VSS.t316 I_x2_core diode_nd2ps_06v0 pj=40u area=99.99999p
X137 a_49772_52654# a_49921_49178# VSS.t253 ppolyf_u_1k r_width=3u r_length=11.55u
X138 perceptron_core_0.voltage_reference_0.v_1_15 a_64353_58580# VSS.t279 VSS.t278 nfet_03v3 ad=1.3p pd=5.52u as=1.3p ps=5.52u w=5u l=1u
X139 perceptron_core_0.gilbert_multiplier_current_1.V_x_n perceptron_core_0.voltage_reference_0.v_1_25 VSS.t254 ppolyf_u_1k r_width=3u r_length=8.1u
X140 VSS.t177 perceptron_core_0.tanh_ota_0.V_ref a_44174_64480# VSS.t176 nfet_03v3 ad=1.04p pd=4.52u as=1.04p ps=4.52u w=4u l=1u
X141 V_out_perceptron.t0 V_out_perceptron_core VDD.t90 ppolyf_u r_width=40u r_length=10u
X142 a_53958_50954# VSS.t154 VSS.t156 VSS.t155 nfet_03v3 ad=0.65p pd=3.02u as=1.525p ps=6.22u w=2.5u l=2u
X143 VDD.t75 a_60034_57400# a_60034_57400# VDD.t74 pfet_03v3 ad=1.3p pd=5.52u as=1.3p ps=5.52u w=5u l=1u
X144 VDD.t66 a_55266_50954# a_55266_50954# VDD.t65 pfet_03v3 ad=2.6p pd=10.52u as=2.6p ps=10.52u w=10u l=2u
X145 a_48342_63968# perceptron_core_0.tanh_ota_0.V_in_p a_50871_64476# VSS.t228 nfet_03v3 ad=1.3p pd=5.52u as=1.3p ps=5.52u w=5u l=0.5u
X146 a_47887_67604# a_52415_68456# VSS.t169 ppolyf_u_1k r_width=3u r_length=22u
X147 VDD.t25 a_55266_65406# a_55266_65406# VDD.t24 pfet_03v3 ad=2.6p pd=10.52u as=2.6p ps=10.52u w=10u l=2u
D22 VSS.t302 I_x1_core diode_nd2ps_06v0 pj=40u area=99.99999p
X148 a_60490_53140# a_67218_53992# VSS.t12 ppolyf_u_1k r_width=3u r_length=33u
X149 a_43293_63442# a_43293_61004# VSS.t305 ppolyf_u_1k r_width=3u r_length=11.55u
D23 V_b_core VDD.t16 diode_pd2nw_06v0 pj=40u area=99.99999p
X150 a_52131_62540# a_52131_62540# VSS.t242 VSS.t241 nfet_03v3 ad=0.39p pd=2.02u as=0.39p ps=2.02u w=1.5u l=0.5u
X151 VSS.t52 VSS.t51 a_44195_67876# VSS.t22 nfet_03v3 ad=3.05p pd=11.22u as=1.3p ps=5.52u w=5u l=0.5u
X152 VSS.t41 VSS.t40 perceptron_core_0.tanh_ota_0.V_in_p VSS.t22 nfet_03v3 ad=1.525p pd=6.22u as=0.65p ps=3.02u w=2.5u l=0.5u
X153 a_44174_64480# perceptron_core_0.voltage_reference_0.v_1_25 a_44195_67876# VSS.t4 nfet_03v3 ad=1.3p pd=5.52u as=1.3p ps=5.52u w=5u l=0.5u
X154 a_44195_67876# V_w1_core perceptron_core_0.tanh_ota_0.V_in_n VSS.t4 nfet_03v3 ad=0.65p pd=3.02u as=0.65p ps=3.02u w=2.5u l=0.5u
X155 a_43293_57348# a_43293_54910# VSS.t209 ppolyf_u_1k r_width=3u r_length=11.55u
X156 VDD.t34 VDD.t32 a_48342_63968# VDD.t33 pfet_03v3 ad=3.25p pd=11.3u as=1.3p ps=5.52u w=5u l=0.5u
X157 VDD.t5 a_54068_69233# perceptron_core_0.voltage_reference_0.v_1_25 VSS.t263 nfet_03v3 ad=2.6p pd=10.52u as=2.6p ps=10.52u w=10u l=1u
X158 VSS.t35 VSS.t34 perceptron_core_0.tanh_ota_0.V_in_p VSS.t22 nfet_03v3 ad=1.525p pd=6.22u as=0.65p ps=3.02u w=2.5u l=0.5u
X159 a_47887_69308# a_52415_70160# VSS.t169 ppolyf_u_1k r_width=3u r_length=22u
X160 VSS.t216 a_52131_62540# a_52131_62540# VSS.t215 nfet_03v3 ad=0.39p pd=2.02u as=0.39p ps=2.02u w=1.5u l=0.5u
X161 a_43991_51280# V_w2_core perceptron_core_0.tanh_ota_0.V_in_p VSS.t150 nfet_03v3 ad=0.65p pd=3.02u as=0.65p ps=3.02u w=2.5u l=0.5u
X162 a_43991_66200# perceptron_core_0.tanh_ota_0.V_ref perceptron_core_0.tanh_ota_0.V_in_n VSS.t4 nfet_03v3 ad=0.65p pd=3.02u as=0.65p ps=3.02u w=2.5u l=0.5u
X163 perceptron_core_0.tanh_ota_0.V_in_n V_w1_core a_44195_67876# VSS.t5 nfet_03v3 ad=0.65p pd=3.02u as=0.65p ps=3.02u w=2.5u l=0.5u
X164 a_43991_51280# perceptron_core_0.tanh_ota_0.V_ref perceptron_core_0.tanh_ota_0.V_in_n VSS.t150 nfet_03v3 ad=0.65p pd=3.02u as=0.65p ps=3.02u w=2.5u l=0.5u
X165 VDD.t101 a_48342_63968# a_48342_63968# VDD.t100 pfet_03v3 ad=1.3p pd=5.52u as=1.3p ps=5.52u w=5u l=0.5u
X166 a_43991_66200# perceptron_core_0.tanh_ota_0.V_ref perceptron_core_0.tanh_ota_0.V_in_n VSS.t173 nfet_03v3 ad=0.65p pd=3.02u as=0.65p ps=3.02u w=2.5u l=0.5u
D24 V_w1_core VDD.t91 diode_pd2nw_06v0 pj=40u area=99.99999p
X167 perceptron_core_0.tanh_ota_0.V_in_p perceptron_core_0.tanh_ota_0.V_ref a_44195_67876# VSS.t49 nfet_03v3 ad=0.65p pd=3.02u as=0.65p ps=3.02u w=2.5u l=0.5u
X168 a_43991_66200# VSS.t16 VSS.t18 VSS.t17 nfet_03v3 ad=1.3p pd=5.52u as=3.05p ps=11.22u w=5u l=0.5u
X169 a_43991_66200# V_w1_core perceptron_core_0.tanh_ota_0.V_in_p VSS.t46 nfet_03v3 ad=0.65p pd=3.02u as=0.65p ps=3.02u w=2.5u l=0.5u
X170 I_x2.t0 I_x2_core VDD.t120 ppolyf_u r_width=40u r_length=10u
X171 a_48233_51616# perceptron_core_0.tanh_ota_0.V_ref VSS.t189 VSS.t134 nfet_03v3 ad=1.04p pd=4.52u as=1.04p ps=4.52u w=4u l=1u
X172 perceptron_core_0.tanh_ota_0.V_in_p VSS.t38 VSS.t39 VSS.t17 nfet_03v3 ad=0.65p pd=3.02u as=1.525p ps=6.22u w=2.5u l=0.5u
D25 V_w2_core VDD.t115 diode_pd2nw_06v0 pj=40u area=99.99999p
X173 a_52131_62540# a_52131_62540# VSS.t214 VSS.t213 nfet_03v3 ad=0.39p pd=2.02u as=0.39p ps=2.02u w=1.5u l=0.5u
D26 V_shift_core VDD.t111 diode_pd2nw_06v0 pj=40u area=99.99999p
X174 VSS.t67 VSS.t65 a_48342_63968# VSS.t66 nfet_03v3 ad=3.05p pd=11.22u as=1.3p ps=5.52u w=5u l=0.5u
X175 a_55266_50954# a_55266_50954# VDD.t60 VDD.t59 pfet_03v3 ad=2.6p pd=10.52u as=2.6p ps=10.52u w=10u l=2u
X176 perceptron_core_0.tanh_ota_0.V_in_p VSS.t32 VSS.t33 VSS.t17 nfet_03v3 ad=0.65p pd=3.02u as=1.525p ps=6.22u w=2.5u l=0.5u
X177 perceptron_core_0.voltage_reference_0.v_1_25 a_54068_69233# VDD.t8 VSS.t266 nfet_03v3 ad=2.6p pd=10.52u as=2.6p ps=10.52u w=10u l=1u
X178 perceptron_core_0.tanh_ota_0.V_in_p perceptron_core_0.tanh_ota_0.V_ref a_44195_47782# VSS.t137 nfet_03v3 ad=0.65p pd=3.02u as=0.65p ps=3.02u w=2.5u l=0.5u
X179 a_52131_62540# a_52131_62540# VSS.t229 VSS.t228 nfet_03v3 ad=0.39p pd=2.02u as=0.39p ps=2.02u w=1.5u l=0.5u
X180 perceptron_core_0.tanh_ota_0.V_in_n V_w2_core a_44195_47782# VSS.t137 nfet_03v3 ad=0.65p pd=3.02u as=0.65p ps=3.02u w=2.5u l=0.5u
X181 a_54068_46311# a_55266_50954# VDD.t64 VDD.t63 pfet_03v3 ad=2.6p pd=10.52u as=2.6p ps=10.52u w=10u l=2u
X182 a_64353_58580# VSS.t86 VSS.t88 VSS.t87 nfet_03v3 ad=1.3p pd=5.52u as=3.05p ps=11.22u w=5u l=1u
D27 V_w2_core VDD.t118 diode_pd2nw_06v0 pj=40u area=99.99999p
X183 a_62490_62184# a_67218_63036# VSS.t271 ppolyf_u_1k r_width=3u r_length=23u
X184 a_43293_54910# perceptron_core_0.gilbert_multiplier_current_1.V_x_n a_43991_51280# VSS.t11 nfet_03v3 ad=1.3p pd=5.52u as=1.3p ps=5.52u w=5u l=0.5u
D28 VSS.t315 V_w2_core diode_nd2ps_06v0 pj=40u area=99.99999p
X185 perceptron_core_0.tanh_ota_0.V_in_n VSS.t97 VSS.t98 VSS.t93 nfet_03v3 ad=0.65p pd=3.02u as=1.525p ps=6.22u w=2.5u l=0.5u
X186 a_53906_63036# a_60034_62184# VSS.t210 ppolyf_u_1k r_width=3u r_length=30u
X187 VDD.t67 VSS.t166 VSS.t168 VSS.t167 nfet_03v3 ad=2.6p pd=10.52u as=6.1p ps=21.22u w=10u l=1u
X188 a_55266_50954# VDD.t56 VDD.t58 VDD.t57 pfet_03v3 ad=2.6p pd=10.52u as=6.5p ps=21.3u w=10u l=2u
D29 I_x1_core VDD.t92 diode_pd2nw_06v0 pj=40u area=99.99999p
D30 VSS.t301 V_w1_core diode_nd2ps_06v0 pj=40u area=99.99999p
X189 V_out_perceptron_core a_48342_63968# VDD.t109 VDD.t108 pfet_03v3 ad=1.3p pd=5.52u as=1.3p ps=5.52u w=5u l=0.5u
X190 perceptron_core_0.tanh_ota_0.V_ref a_54068_46311# VDD.t83 VSS.t294 nfet_03v3 ad=2.6p pd=10.52u as=2.6p ps=10.52u w=10u l=1u
D31 VSS.t313 V_w2_core diode_nd2ps_06v0 pj=40u area=99.99999p
X191 perceptron_core_0.voltage_reference_0.v_1_15 perceptron_core_0.voltage_reference_0.v_1_15 a_62775_58580# VDD.t2 pfet_03v3 ad=2.6p pd=10.52u as=2.6p ps=10.52u w=10u l=1u
X192 VSS.t153 VSS.t152 perceptron_core_0.tanh_ota_0.V_in_p VSS.t150 nfet_03v3 ad=1.525p pd=6.22u as=0.65p ps=3.02u w=2.5u l=0.5u
D32 I_x2_core VDD.t122 diode_pd2nw_06v0 pj=40u area=99.99999p
X193 VSS.t94 VSS.t92 perceptron_core_0.tanh_ota_0.V_in_n VSS.t93 nfet_03v3 ad=1.525p pd=6.22u as=0.65p ps=3.02u w=2.5u l=0.5u
X194 a_55134_51058# a_60043_58514# VSS.t280 ppolyf_u_1k r_width=3u r_length=20u
D33 V_shift_core VDD.t111 diode_pd2nw_06v0 pj=40u area=99.99999p
X195 V_shift_core perceptron_core_0.tanh_ota_0.V_in_p VSS.t1 ppolyf_u_1k r_width=3u r_length=7.3u
X196 a_43991_51280# perceptron_core_0.tanh_ota_0.V_ref perceptron_core_0.tanh_ota_0.V_in_n VSS.t150 nfet_03v3 ad=0.65p pd=3.02u as=0.65p ps=3.02u w=2.5u l=0.5u
X197 a_49135_56824# V_b_core perceptron_core_0.tanh_ota_0.V_in_p VSS.t93 nfet_03v3 ad=0.65p pd=3.02u as=0.65p ps=3.02u w=2.5u l=0.5u
X198 VSS.t25 VSS.t24 perceptron_core_0.tanh_ota_0.V_in_n VSS.t22 nfet_03v3 ad=1.525p pd=6.22u as=0.65p ps=3.02u w=2.5u l=0.5u
X199 perceptron_core_0.tanh_ota_0.V_in_n V_w1_core a_44195_67876# VSS.t172 nfet_03v3 ad=0.65p pd=3.02u as=0.65p ps=3.02u w=2.5u l=0.5u
X200 a_53906_54844# a_60034_55696# VSS.t0 ppolyf_u_1k r_width=3u r_length=30u
X201 a_44195_47782# V_w2_core perceptron_core_0.tanh_ota_0.V_in_n VSS.t128 nfet_03v3 ad=0.65p pd=3.02u as=0.65p ps=3.02u w=2.5u l=0.5u
X202 a_43991_66200# V_w1_core perceptron_core_0.tanh_ota_0.V_in_p VSS.t4 nfet_03v3 ad=0.65p pd=3.02u as=0.65p ps=3.02u w=2.5u l=0.5u
X203 a_43293_54910# perceptron_core_0.tanh_ota_0.V_ref VSS.t185 VSS.t108 nfet_03v3 ad=1.04p pd=4.52u as=1.04p ps=4.52u w=4u l=1u
X204 a_64353_58580# a_64353_58580# VSS.t273 VSS.t272 nfet_03v3 ad=1.3p pd=5.52u as=1.3p ps=5.52u w=5u l=1u
X205 VSS.t227 a_52131_62540# a_52131_62540# VSS.t66 nfet_03v3 ad=0.39p pd=2.02u as=0.39p ps=2.02u w=1.5u l=0.5u
X206 a_44137_63442# a_44981_61004# VSS.t305 ppolyf_u_1k r_width=3u r_length=11.55u
X207 a_44195_47782# perceptron_core_0.tanh_ota_0.V_ref perceptron_core_0.tanh_ota_0.V_in_p VSS.t128 nfet_03v3 ad=0.65p pd=3.02u as=0.65p ps=3.02u w=2.5u l=0.5u
X208 I_x2_core perceptron_core_0.voltage_reference_0.v_1_25 perceptron_core_0.gilbert_multiplier_current_1.V_x_n VSS.t9 nfet_03v3 ad=1.525p pd=6.22u as=0.65p ps=3.02u w=2.5u l=0.5u
D34 I_x1_core VDD.t92 diode_pd2nw_06v0 pj=40u area=99.99999p
X209 a_43991_66200# perceptron_core_0.gilbert_multiplier_current_2.V_x_n a_43293_63442# VSS.t170 nfet_03v3 ad=1.3p pd=5.52u as=1.3p ps=5.52u w=5u l=0.5u
X210 V_w1.t0 V_w1_core VDD.t93 ppolyf_u r_width=40u r_length=10u
X211 perceptron_core_0.tanh_ota_0.V_in_n V_w1_core a_44195_67876# VSS.t170 nfet_03v3 ad=0.65p pd=3.02u as=0.65p ps=3.02u w=2.5u l=0.5u
X212 a_43991_51280# perceptron_core_0.tanh_ota_0.V_ref perceptron_core_0.tanh_ota_0.V_in_n VSS.t125 nfet_03v3 ad=0.65p pd=3.02u as=0.65p ps=3.02u w=2.5u l=0.5u
X213 a_48931_54374# VSS.t112 VSS.t113 VSS.t10 nfet_03v3 ad=1.3p pd=5.52u as=3.05p ps=11.22u w=5u l=0.5u
X214 VDD.t43 VDD.t41 a_60034_57400# VDD.t42 pfet_03v3 ad=3.25p pd=11.3u as=1.3p ps=5.52u w=5u l=1u
X215 V_out_perceptron_core a_49529_59702# VSS.t260 ppolyf_u_1k r_width=3u r_length=15u
X216 a_43991_51280# V_w2_core perceptron_core_0.tanh_ota_0.V_in_p VSS.t125 nfet_03v3 ad=0.65p pd=3.02u as=0.65p ps=3.02u w=2.5u l=0.5u
D35 VSS.t301 V_w1_core diode_nd2ps_06v0 pj=40u area=99.99999p
X217 perceptron_core_0.tanh_ota_0.V_in_p VSS.t149 VSS.t151 VSS.t150 nfet_03v3 ad=0.65p pd=3.02u as=1.525p ps=6.22u w=2.5u l=0.5u
X218 a_44981_57348# a_44137_54910# VSS.t209 ppolyf_u_1k r_width=3u r_length=11.55u
X219 perceptron_core_0.tanh_ota_0.V_in_n perceptron_core_0.tanh_ota_0.V_ref a_43991_66200# VSS.t170 nfet_03v3 ad=0.65p pd=3.02u as=0.65p ps=3.02u w=2.5u l=0.5u
X220 a_60490_54844# a_67218_55696# VSS.t12 ppolyf_u_1k r_width=3u r_length=33u
D36 I_x1_core VDD.t92 diode_pd2nw_06v0 pj=40u area=99.99999p
X221 perceptron_core_0.tanh_ota_0.V_in_p perceptron_core_0.tanh_ota_0.V_ref a_44195_47782# VSS.t137 nfet_03v3 ad=0.65p pd=3.02u as=0.65p ps=3.02u w=2.5u l=0.5u
X222 perceptron_core_0.tanh_ota_0.V_in_p VSS.t89 VSS.t91 VSS.t90 nfet_03v3 ad=0.65p pd=3.02u as=1.525p ps=6.22u w=2.5u l=0.5u
X223 perceptron_core_0.tanh_ota_0.V_in_n VSS.t36 VSS.t37 VSS.t17 nfet_03v3 ad=0.65p pd=3.02u as=1.525p ps=6.22u w=2.5u l=0.5u
X224 a_52131_62540# a_52131_62540# VSS.t234 VSS.t233 nfet_03v3 ad=0.39p pd=2.02u as=0.39p ps=2.02u w=1.5u l=0.5u
X225 a_44195_67876# V_w1_core perceptron_core_0.tanh_ota_0.V_in_n VSS.t171 nfet_03v3 ad=0.65p pd=3.02u as=0.65p ps=3.02u w=2.5u l=0.5u
X226 a_48342_63968# a_48342_63968# VDD.t95 VDD.t94 pfet_03v3 ad=1.3p pd=5.52u as=1.3p ps=5.52u w=5u l=0.5u
X227 VSS.t119 VSS.t118 a_49135_56824# VSS.t10 nfet_03v3 ad=3.05p pd=11.22u as=1.3p ps=5.52u w=5u l=0.5u
X228 a_48233_51616# VSS.t143 VSS.t144 VSS.t134 nfet_03v3 ad=1.04p pd=4.52u as=2.44p ps=9.22u w=4u l=1u
X229 perceptron_core_0.tanh_ota_0.V_in_n perceptron_core_0.tanh_ota_0.V_ref a_49135_56824# VSS.t93 nfet_03v3 ad=0.65p pd=3.02u as=0.65p ps=3.02u w=2.5u l=0.5u
X230 I_x1_core perceptron_core_0.voltage_reference_0.v_1_25 perceptron_core_0.gilbert_multiplier_current_2.V_x_n VSS.t6 nfet_03v3 ad=1.525p pd=6.22u as=0.65p ps=3.02u w=2.5u l=0.5u
X231 a_49772_52654# perceptron_core_0.voltage_reference_0.v_1_15 a_49135_56824# VSS.t10 nfet_03v3 ad=1.3p pd=5.52u as=1.3p ps=5.52u w=5u l=0.5u
X232 a_50871_64476# perceptron_core_0.tanh_ota_0.V_in_n V_out_perceptron_core VSS.t235 nfet_03v3 ad=1.3p pd=5.52u as=1.3p ps=5.52u w=5u l=0.5u
X233 perceptron_core_0.tanh_ota_0.V_in_p V_b_core a_49135_56824# VSS.t93 nfet_03v3 ad=0.65p pd=3.02u as=0.65p ps=3.02u w=2.5u l=0.5u
X234 a_43293_63442# perceptron_core_0.tanh_ota_0.V_ref VSS.t175 VSS.t174 nfet_03v3 ad=1.04p pd=4.52u as=1.04p ps=4.52u w=4u l=1u
X235 VSS.t220 a_52131_62540# a_52131_62540# VSS.t219 nfet_03v3 ad=0.39p pd=2.02u as=0.39p ps=2.02u w=1.5u l=0.5u
X236 VSS.t96 VSS.t95 perceptron_core_0.tanh_ota_0.V_in_p VSS.t90 nfet_03v3 ad=1.525p pd=6.22u as=0.65p ps=3.02u w=2.5u l=0.5u
X237 VSS.t244 a_52131_62540# a_52131_62540# VSS.t243 nfet_03v3 ad=0.39p pd=2.02u as=0.39p ps=2.02u w=1.5u l=0.5u
X238 a_47887_67604# a_52131_62540# VSS.t169 ppolyf_u_1k r_width=3u r_length=22u
X239 a_44195_47782# perceptron_core_0.tanh_ota_0.V_ref perceptron_core_0.tanh_ota_0.V_in_p VSS.t137 nfet_03v3 ad=0.65p pd=3.02u as=0.65p ps=3.02u w=2.5u l=0.5u
X240 a_49135_56824# perceptron_core_0.tanh_ota_0.V_ref perceptron_core_0.tanh_ota_0.V_in_n VSS.t90 nfet_03v3 ad=0.65p pd=3.02u as=0.65p ps=3.02u w=2.5u l=0.5u
X241 a_53826_51058# VSS.t83 VSS.t85 VSS.t84 nfet_03v3 ad=1.3p pd=5.52u as=3.05p ps=11.22u w=5u l=1u
X242 VDD.t88 a_54068_46311# perceptron_core_0.tanh_ota_0.V_ref VSS.t299 nfet_03v3 ad=2.6p pd=10.52u as=2.6p ps=10.52u w=10u l=1u
X243 I_x1.t0 I_x1_core VDD.t113 ppolyf_u r_width=40u r_length=10u
X244 a_64353_58580# VDD.t54 VDD.t55 VDD.t2 pfet_03v3 ad=2.6p pd=10.52u as=6.5p ps=21.3u w=10u l=1u
D37 V_w2_core VDD.t117 diode_pd2nw_06v0 pj=40u area=99.99999p
X245 a_52131_62540# a_52131_62540# VSS.t218 VSS.t217 nfet_03v3 ad=0.39p pd=2.02u as=0.39p ps=2.02u w=1.5u l=0.5u
X246 VSS.t129 VSS.t127 perceptron_core_0.tanh_ota_0.V_in_n VSS.t128 nfet_03v3 ad=1.525p pd=6.22u as=0.65p ps=3.02u w=2.5u l=0.5u
X247 perceptron_core_0.voltage_reference_0.v_1_25 a_54068_69233# VDD.t6 VSS.t264 nfet_03v3 ad=2.6p pd=10.52u as=2.6p ps=10.52u w=10u l=1u
X248 perceptron_core_0.tanh_ota_0.V_ref a_54068_46311# VDD.t81 VSS.t292 nfet_03v3 ad=2.6p pd=10.52u as=2.6p ps=10.52u w=10u l=1u
D38 VSS.t283 V_b_core diode_nd2ps_06v0 pj=40u area=99.99999p
X249 a_44195_47782# perceptron_core_0.tanh_ota_0.V_ref perceptron_core_0.tanh_ota_0.V_in_p VSS.t128 nfet_03v3 ad=0.65p pd=3.02u as=0.65p ps=3.02u w=2.5u l=0.5u
X250 a_48342_63968# VDD.t35 VDD.t37 VDD.t36 pfet_03v3 ad=1.3p pd=5.52u as=3.25p ps=11.3u w=5u l=0.5u
X251 perceptron_core_0.tanh_ota_0.V_in_p VSS.t99 VSS.t101 VSS.t100 nfet_03v3 ad=0.65p pd=3.02u as=1.525p ps=6.22u w=2.5u l=0.5u
D39 V_shift_core VDD.t111 diode_pd2nw_06v0 pj=40u area=99.99999p
D40 I_x1_core VDD.t92 diode_pd2nw_06v0 pj=40u area=99.99999p
X252 VDD.t78 a_60034_57400# a_62775_58580# VDD.t48 pfet_03v3 ad=1.3p pd=5.52u as=1.3p ps=5.52u w=5u l=1u
X253 VSS.t126 VSS.t124 perceptron_core_0.tanh_ota_0.V_in_n VSS.t125 nfet_03v3 ad=1.525p pd=6.22u as=0.65p ps=3.02u w=2.5u l=0.5u
D41 VSS.t281 V_b_core diode_nd2ps_06v0 pj=40u area=99.99999p
X254 a_43991_51280# V_w2_core perceptron_core_0.tanh_ota_0.V_in_p VSS.t125 nfet_03v3 ad=0.65p pd=3.02u as=0.65p ps=3.02u w=2.5u l=0.5u
X255 a_60490_53140# VDD.t119 VSS.t12 ppolyf_u_1k r_width=3u r_length=33u
D42 VSS.t301 V_w1_core diode_nd2ps_06v0 pj=40u area=99.99999p
X256 a_48931_54374# perceptron_core_0.voltage_reference_0.v_1_25 a_48233_51616# VSS.t10 nfet_03v3 ad=1.3p pd=5.52u as=1.3p ps=5.52u w=5u l=0.5u
X257 a_44137_63442# a_43293_61004# VSS.t305 ppolyf_u_1k r_width=3u r_length=11.55u
X258 perceptron_core_0.tanh_ota_0.V_in_n perceptron_core_0.tanh_ota_0.V_ref a_43991_51280# VSS.t150 nfet_03v3 ad=0.65p pd=3.02u as=0.65p ps=3.02u w=2.5u l=0.5u
X259 perceptron_core_0.tanh_ota_0.V_in_p V_b_core a_49135_56824# VSS.t90 nfet_03v3 ad=0.65p pd=3.02u as=0.65p ps=3.02u w=2.5u l=0.5u
X260 perceptron_core_0.tanh_ota_0.V_in_n VSS.t161 VSS.t162 VSS.t128 nfet_03v3 ad=0.65p pd=3.02u as=1.525p ps=6.22u w=2.5u l=0.5u
X261 VSS.t103 VSS.t102 perceptron_core_0.tanh_ota_0.V_in_p VSS.t100 nfet_03v3 ad=1.525p pd=6.22u as=0.65p ps=3.02u w=2.5u l=0.5u
X262 perceptron_core_0.tanh_ota_0.V_in_n perceptron_core_0.tanh_ota_0.V_ref a_49135_56824# VSS.t90 nfet_03v3 ad=0.65p pd=3.02u as=0.65p ps=3.02u w=2.5u l=0.5u
X263 perceptron_core_0.tanh_ota_0.V_in_p V_w1_core a_43991_66200# VSS.t170 nfet_03v3 ad=0.65p pd=3.02u as=0.65p ps=3.02u w=2.5u l=0.5u
X264 VSS.t236 a_52131_62540# a_50871_64476# VSS.t235 nfet_03v3 ad=0.39p pd=2.02u as=0.39p ps=2.02u w=1.5u l=0.5u
X265 a_43293_57348# a_44137_54910# VSS.t209 ppolyf_u_1k r_width=3u r_length=11.55u
X266 a_49077_51616# a_48233_49178# VSS.t253 ppolyf_u_1k r_width=3u r_length=11.55u
X267 a_48931_54374# V_b_core perceptron_core_0.tanh_ota_0.V_in_n VSS.t100 nfet_03v3 ad=0.65p pd=3.02u as=0.65p ps=3.02u w=2.5u l=0.5u
X268 a_64353_58580# a_60430_60950# a_62775_58580# VDD.t2 pfet_03v3 ad=2.6p pd=10.52u as=2.6p ps=10.52u w=10u l=1u
X269 perceptron_core_0.tanh_ota_0.V_in_n VSS.t147 VSS.t148 VSS.t125 nfet_03v3 ad=0.65p pd=3.02u as=1.525p ps=6.22u w=2.5u l=0.5u
X270 a_48233_51616# a_48233_49178# VSS.t253 ppolyf_u_1k r_width=3u r_length=11.55u
X271 perceptron_core_0.tanh_ota_0.V_in_n VSS.t26 VSS.t28 VSS.t27 nfet_03v3 ad=0.65p pd=3.02u as=1.525p ps=6.22u w=2.5u l=0.5u
D43 VSS.t306 V_shift_core diode_nd2ps_06v0 pj=40u area=99.99999p
X272 VDD.t0 perceptron_core_0.tanh_ota_0.V_in_n VSS.t1 ppolyf_u_1k r_width=3u r_length=7.3u
X273 a_44195_67876# perceptron_core_0.voltage_reference_0.v_1_25 a_44174_64480# VSS.t5 nfet_03v3 ad=1.3p pd=5.52u as=1.3p ps=5.52u w=5u l=0.5u
D44 V_w1_core VDD.t91 diode_pd2nw_06v0 pj=40u area=99.99999p
X274 a_52131_62540# a_52131_62540# VSS.t248 VSS.t247 nfet_03v3 ad=0.39p pd=2.02u as=0.39p ps=2.02u w=1.5u l=0.5u
X275 perceptron_core_0.tanh_ota_0.V_in_p perceptron_core_0.tanh_ota_0.V_ref a_44195_67876# VSS.t5 nfet_03v3 ad=0.65p pd=3.02u as=0.65p ps=3.02u w=2.5u l=0.5u
X276 a_44195_67876# VSS.t48 VSS.t50 VSS.t49 nfet_03v3 ad=1.3p pd=5.52u as=3.05p ps=11.22u w=5u l=0.5u
X277 V_out_perceptron_core a_48342_63968# VDD.t103 VDD.t102 pfet_03v3 ad=1.3p pd=5.52u as=1.3p ps=5.52u w=5u l=0.5u
X278 perceptron_core_0.tanh_ota_0.V_in_n V_w1_core a_44195_67876# VSS.t49 nfet_03v3 ad=0.65p pd=3.02u as=0.65p ps=3.02u w=2.5u l=0.5u
X279 a_50381_62830# perceptron_core_0.tanh_ota_0.V_ref VSS.t260 ppolyf_u_1k r_width=3u r_length=15u
X280 VSS.t111 VSS.t110 a_44174_53200# VSS.t108 nfet_03v3 ad=2.44p pd=9.22u as=1.04p ps=4.52u w=4u l=1u
X281 perceptron_core_0.tanh_ota_0.V_in_p V_w1_core a_43991_66200# VSS.t5 nfet_03v3 ad=0.65p pd=3.02u as=0.65p ps=3.02u w=2.5u l=0.5u
X282 V_b.t0 V_b_core VDD.t70 ppolyf_u r_width=40u r_length=10u
X283 VSS.t82 VSS.t81 perceptron_core_0.tanh_ota_0.V_in_n VSS.t27 nfet_03v3 ad=1.525p pd=6.22u as=0.65p ps=3.02u w=2.5u l=0.5u
X284 perceptron_core_0.tanh_ota_0.V_in_n perceptron_core_0.tanh_ota_0.V_ref a_43991_66200# VSS.t49 nfet_03v3 ad=0.65p pd=3.02u as=0.65p ps=3.02u w=2.5u l=0.5u
X285 a_53826_51058# a_60034_60480# VSS.t192 ppolyf_u_1k r_width=3u r_length=30u
D45 I_x2_core VDD.t121 diode_pd2nw_06v0 pj=40u area=99.99999p
X286 a_48931_54374# perceptron_core_0.tanh_ota_0.V_ref perceptron_core_0.tanh_ota_0.V_in_p VSS.t27 nfet_03v3 ad=0.65p pd=3.02u as=0.65p ps=3.02u w=2.5u l=0.5u
X287 perceptron_core_0.tanh_ota_0.V_in_p perceptron_core_0.tanh_ota_0.V_ref a_48931_54374# VSS.t100 nfet_03v3 ad=0.65p pd=3.02u as=0.65p ps=3.02u w=2.5u l=0.5u
X288 perceptron_core_0.tanh_ota_0.V_in_n V_b_core a_48931_54374# VSS.t100 nfet_03v3 ad=0.65p pd=3.02u as=0.65p ps=3.02u w=2.5u l=0.5u
X289 VSS.t123 VSS.t122 a_43991_51280# VSS.t11 nfet_03v3 ad=3.05p pd=11.22u as=1.3p ps=5.52u w=5u l=0.5u
X290 a_53906_56548# a_60034_57400# VSS.t259 ppolyf_u_1k r_width=3u r_length=30u
X291 VSS.t3 perceptron_core_0.voltage_reference_0.v_1_25 VSS.t2 ppolyf_u_1k r_width=3u r_length=20u
X292 a_53906_54844# a_60034_53992# VSS.t256 ppolyf_u_1k r_width=3u r_length=30u
X293 VDD.t49 VDD.t47 a_62775_58580# VDD.t48 pfet_03v3 ad=3.25p pd=11.3u as=1.3p ps=5.52u w=5u l=1u
X294 VSS.t78 VSS.t77 a_55266_65406# VSS.t72 nfet_03v3 ad=3.05p pd=11.22u as=1.3p ps=5.52u w=5u l=2u
D46 I_x2_core VDD.t124 diode_pd2nw_06v0 pj=40u area=99.99999p
X295 perceptron_core_0.voltage_reference_0.v_1_25 a_54068_69233# VDD.t4 VSS.t262 nfet_03v3 ad=2.6p pd=10.52u as=2.6p ps=10.52u w=10u l=1u
X296 a_52131_62540# a_52131_62540# VSS.t222 VSS.t221 nfet_03v3 ad=0.39p pd=2.02u as=0.39p ps=2.02u w=1.5u l=0.5u
X297 VSS.t188 perceptron_core_0.tanh_ota_0.V_ref a_49772_52654# VSS.t134 nfet_03v3 ad=1.04p pd=4.52u as=1.04p ps=4.52u w=4u l=1u
X298 a_50871_64476# perceptron_core_0.tanh_ota_0.V_in_p a_48342_63968# VSS.t230 nfet_03v3 ad=1.3p pd=5.52u as=1.3p ps=5.52u w=5u l=0.5u
X299 perceptron_core_0.voltage_reference_0.v_1_25 a_54068_69233# VDD.t12 VSS.t270 nfet_03v3 ad=2.6p pd=10.52u as=2.6p ps=10.52u w=10u l=1u
X300 a_47887_69308# a_52415_68456# VSS.t169 ppolyf_u_1k r_width=3u r_length=22u
D47 VSS.t319 I_x2_core diode_nd2ps_06v0 pj=40u area=99.99999p
X301 perceptron_core_0.tanh_ota_0.V_in_p perceptron_core_0.tanh_ota_0.V_ref a_44195_47782# VSS.t128 nfet_03v3 ad=0.65p pd=3.02u as=0.65p ps=3.02u w=2.5u l=0.5u
X302 a_53958_65406# perceptron_core_0.voltage_reference_0.v_1_25 a_54068_69233# VSS.t7 nfet_03v3 ad=1.3p pd=5.52u as=1.3p ps=5.52u w=5u l=2u
X303 VSS.t64 VSS.t62 a_44174_64480# VSS.t63 nfet_03v3 ad=2.44p pd=9.22u as=1.04p ps=4.52u w=4u l=1u
X304 VSS.t246 a_52131_62540# a_52131_62540# VSS.t245 nfet_03v3 ad=0.39p pd=2.02u as=0.39p ps=2.02u w=1.5u l=0.5u
D48 V_out_perceptron_core VDD.t114 diode_pd2nw_06v0 pj=40u area=99.99999p
D49 VSS.t306 V_shift_core diode_nd2ps_06v0 pj=40u area=99.99999p
X305 a_44174_53200# VSS.t107 VSS.t109 VSS.t108 nfet_03v3 ad=1.04p pd=4.52u as=2.44p ps=9.22u w=4u l=1u
X306 a_53826_51058# a_53826_51058# VSS.t194 VSS.t193 nfet_03v3 ad=1.3p pd=5.52u as=1.3p ps=5.52u w=5u l=1u
X307 a_60490_54844# a_67218_53992# VSS.t12 ppolyf_u_1k r_width=3u r_length=33u
X308 VDD.t97 a_48342_63968# V_out_perceptron_core VDD.t96 pfet_03v3 ad=1.3p pd=5.52u as=1.3p ps=5.52u w=5u l=0.5u
X309 perceptron_core_0.tanh_ota_0.V_in_p V_w2_core a_43991_51280# VSS.t125 nfet_03v3 ad=0.65p pd=3.02u as=0.65p ps=3.02u w=2.5u l=0.5u
X310 VDD.t86 a_54068_46311# perceptron_core_0.tanh_ota_0.V_ref VSS.t297 nfet_03v3 ad=2.6p pd=10.52u as=2.6p ps=10.52u w=10u l=1u
X311 perceptron_core_0.tanh_ota_0.V_in_n V_b_core a_48931_54374# VSS.t27 nfet_03v3 ad=0.65p pd=3.02u as=0.65p ps=3.02u w=2.5u l=0.5u
D50 VSS.t317 I_x2_core diode_nd2ps_06v0 pj=40u area=99.99999p
D51 VSS.t306 V_shift_core diode_nd2ps_06v0 pj=40u area=99.99999p
X312 perceptron_core_0.tanh_ota_0.V_in_p perceptron_core_0.tanh_ota_0.V_ref a_48931_54374# VSS.t27 nfet_03v3 ad=0.65p pd=3.02u as=0.65p ps=3.02u w=2.5u l=0.5u
X313 V_out_perceptron_core perceptron_core_0.tanh_ota_0.V_in_n a_50871_64476# VSS.t237 nfet_03v3 ad=1.3p pd=5.52u as=1.3p ps=5.52u w=5u l=0.5u
X314 VSS.t73 VSS.t71 a_53958_65406# VSS.t72 nfet_03v3 ad=1.525p pd=6.22u as=0.65p ps=3.02u w=2.5u l=2u
X315 a_44174_64480# a_44981_61004# VSS.t305 ppolyf_u_1k r_width=3u r_length=11.55u
X316 VSS.t165 VSS.t163 VDD.t69 VSS.t164 nfet_03v3 ad=6.1p pd=21.22u as=2.6p ps=10.52u w=10u l=1u
X317 VDD.t13 a_52415_70160# VSS.t169 ppolyf_u_1k r_width=3u r_length=22u
D52 V_b_core VDD.t15 diode_pd2nw_06v0 pj=40u area=99.99999p
X318 perceptron_core_0.tanh_ota_0.V_in_p perceptron_core_0.tanh_ota_0.V_ref a_44195_67876# VSS.t172 nfet_03v3 ad=0.65p pd=3.02u as=0.65p ps=3.02u w=2.5u l=0.5u
X319 VDD.t76 a_60034_57400# a_62775_58580# VDD.t48 pfet_03v3 ad=1.3p pd=5.52u as=1.3p ps=5.52u w=5u l=1u
X320 VSS.t197 a_53826_51058# a_53958_65406# VSS.t7 nfet_03v3 ad=0.65p pd=3.02u as=0.65p ps=3.02u w=2.5u l=2u
X321 VSS.t275 a_64353_58580# a_64353_58580# VSS.t274 nfet_03v3 ad=1.3p pd=5.52u as=1.3p ps=5.52u w=5u l=1u
X322 perceptron_core_0.tanh_ota_0.V_in_p V_w2_core a_43991_51280# VSS.t150 nfet_03v3 ad=0.65p pd=3.02u as=0.65p ps=3.02u w=2.5u l=0.5u
X323 perceptron_core_0.tanh_ota_0.V_in_n perceptron_core_0.tanh_ota_0.V_ref a_49135_56824# VSS.t93 nfet_03v3 ad=0.65p pd=3.02u as=0.65p ps=3.02u w=2.5u l=0.5u
X324 a_44981_57348# a_44174_53200# VSS.t209 ppolyf_u_1k r_width=3u r_length=11.55u
X325 perceptron_core_0.tanh_ota_0.V_in_p V_w1_core a_43991_66200# VSS.t172 nfet_03v3 ad=0.65p pd=3.02u as=0.65p ps=3.02u w=2.5u l=0.5u
X326 a_44195_67876# V_w1_core perceptron_core_0.tanh_ota_0.V_in_n VSS.t173 nfet_03v3 ad=0.65p pd=3.02u as=0.65p ps=3.02u w=2.5u l=0.5u
X327 perceptron_core_0.tanh_ota_0.V_in_p V_b_core a_49135_56824# VSS.t93 nfet_03v3 ad=0.65p pd=3.02u as=0.65p ps=3.02u w=2.5u l=0.5u
X328 perceptron_core_0.tanh_ota_0.V_in_n perceptron_core_0.tanh_ota_0.V_ref a_43991_51280# VSS.t150 nfet_03v3 ad=0.65p pd=3.02u as=0.65p ps=3.02u w=2.5u l=0.5u
X329 a_49077_51616# a_49921_49178# VSS.t253 ppolyf_u_1k r_width=3u r_length=11.55u
X330 perceptron_core_0.tanh_ota_0.V_in_n perceptron_core_0.tanh_ota_0.V_ref a_43991_66200# VSS.t5 nfet_03v3 ad=0.65p pd=3.02u as=0.65p ps=3.02u w=2.5u l=0.5u
X331 a_60034_57400# VDD.t44 VDD.t46 VDD.t45 pfet_03v3 ad=1.3p pd=5.52u as=3.25p ps=11.3u w=5u l=1u
X332 a_44195_67876# perceptron_core_0.tanh_ota_0.V_ref perceptron_core_0.tanh_ota_0.V_in_p VSS.t46 nfet_03v3 ad=0.65p pd=3.02u as=0.65p ps=3.02u w=2.5u l=0.5u
X333 VSS.t142 VSS.t141 a_44195_47782# VSS.t11 nfet_03v3 ad=3.05p pd=11.22u as=1.3p ps=5.52u w=5u l=0.5u
X334 a_44174_64480# VSS.t59 VSS.t61 VSS.t60 nfet_03v3 ad=1.04p pd=4.52u as=2.44p ps=9.22u w=4u l=1u
X335 perceptron_core_0.tanh_ota_0.V_in_p V_w1_core a_43991_66200# VSS.t49 nfet_03v3 ad=0.65p pd=3.02u as=0.65p ps=3.02u w=2.5u l=0.5u
X336 a_44174_53200# perceptron_core_0.voltage_reference_0.v_1_25 a_44195_47782# VSS.t11 nfet_03v3 ad=1.3p pd=5.52u as=1.3p ps=5.52u w=5u l=0.5u
X337 perceptron_core_0.gilbert_multiplier_current_1.V_x_n perceptron_core_0.voltage_reference_0.v_1_25 I_x2_core VSS.t9 nfet_03v3 ad=0.65p pd=3.02u as=1.525p ps=6.22u w=2.5u l=0.5u
X338 a_43293_63442# perceptron_core_0.gilbert_multiplier_current_2.V_x_n a_43991_66200# VSS.t171 nfet_03v3 ad=1.3p pd=5.52u as=1.3p ps=5.52u w=5u l=0.5u
X339 a_44195_67876# perceptron_core_0.tanh_ota_0.V_ref perceptron_core_0.tanh_ota_0.V_in_p VSS.t171 nfet_03v3 ad=0.65p pd=3.02u as=0.65p ps=3.02u w=2.5u l=0.5u
X340 a_62490_63888# VSS.t303 VSS.t271 ppolyf_u_1k r_width=3u r_length=23u
X341 VDD.t82 a_54068_46311# perceptron_core_0.tanh_ota_0.V_ref VSS.t293 nfet_03v3 ad=2.6p pd=10.52u as=2.6p ps=10.52u w=10u l=1u
X342 VSS.t231 a_52131_62540# a_52131_62540# VSS.t230 nfet_03v3 ad=0.39p pd=2.02u as=0.39p ps=2.02u w=1.5u l=0.5u
D53 V_out_perceptron_core VDD.t114 diode_pd2nw_06v0 pj=40u area=99.99999p
D54 V_out_perceptron_core VDD.t114 diode_pd2nw_06v0 pj=40u area=99.99999p
X343 a_43991_66200# V_w1_core perceptron_core_0.tanh_ota_0.V_in_p VSS.t171 nfet_03v3 ad=0.65p pd=3.02u as=0.65p ps=3.02u w=2.5u l=0.5u
D55 VSS.t314 V_w2_core diode_nd2ps_06v0 pj=40u area=99.99999p
X344 a_44195_47782# perceptron_core_0.tanh_ota_0.V_ref perceptron_core_0.tanh_ota_0.V_in_p VSS.t137 nfet_03v3 ad=0.65p pd=3.02u as=0.65p ps=3.02u w=2.5u l=0.5u
X345 VSS.t135 VSS.t133 a_48233_51616# VSS.t134 nfet_03v3 ad=2.44p pd=9.22u as=1.04p ps=4.52u w=4u l=1u
X346 a_44195_47782# V_w2_core perceptron_core_0.tanh_ota_0.V_in_n VSS.t137 nfet_03v3 ad=0.65p pd=3.02u as=0.65p ps=3.02u w=2.5u l=0.5u
X347 a_43991_51280# VSS.t120 VSS.t121 VSS.t11 nfet_03v3 ad=1.3p pd=5.52u as=3.05p ps=11.22u w=5u l=0.5u
R0 V_w2 V_w2.t0 0.221654
R1 I_x2 I_x2.t0 0.221654
R2 V_b V_b.t0 0.221654
R3 I_x1.n0 I_x1 2.58175
R4 I_x1.n0 I_x1.t0 0.213633
R5 I_x1 I_x1.n0 0.0185857
R6 V_out_perceptron.n0 V_out_perceptron.t0 0.213633
R7 V_out_perceptron.n0 V_out_perceptron 0.0635
R8 V_out_perceptron V_out_perceptron.n0 0.0185857
R9 V_shift.n0 V_shift.t0 0.213633
R10 V_shift.n0 V_shift 0.0710429
R11 V_shift V_shift.n0 0.0185857
R12 V_w1 V_w1.t0 0.221654
R13 VDD.n572 VDD.n550 489.601
R14 VDD.t118 VDD.n307 471.089
R15 VDD.t117 VDD.n307 471.089
R16 VDD.t117 VDD.n300 471.089
R17 VDD.t116 VDD.n300 471.089
R18 VDD.t116 VDD.n301 471.089
R19 VDD.t115 VDD.n301 471.089
R20 VDD.t124 VDD.n183 471.089
R21 VDD.t123 VDD.n183 471.089
R22 VDD.t123 VDD.n176 471.089
R23 VDD.t122 VDD.n176 471.089
R24 VDD.t122 VDD.n177 471.089
R25 VDD.t121 VDD.n177 471.089
R26 VDD.t17 VDD.n231 471.089
R27 VDD.t16 VDD.n231 471.089
R28 VDD.t16 VDD.n224 471.089
R29 VDD.t15 VDD.n224 471.089
R30 VDD.t15 VDD.n225 471.089
R31 VDD.t14 VDD.n225 471.089
R32 VDD.n292 VDD.n168 470.575
R33 VDD.n289 VDD.n169 470.575
R34 VDD.n283 VDD.n217 470.575
R35 VDD.n280 VDD.n218 470.575
R36 VDD.n273 VDD.n265 470.575
R37 VDD.n270 VDD.n266 470.575
R38 VDD.n5 VDD.n4 470.575
R39 VDD.n9 VDD.n8 470.575
R40 VDD.n664 VDD.n663 470.575
R41 VDD.n668 VDD.n667 470.575
R42 VDD.n777 VDD.n776 470.575
R43 VDD.n781 VDD.n780 470.575
R44 VDD.n722 VDD.n721 470.575
R45 VDD.n726 VDD.n725 470.575
R46 VDD.t2 VDD.n558 464.3
R47 VDD.n5 VDD.n2 362.409
R48 VDD.n9 VDD.n1 362.409
R49 VDD.n664 VDD.n661 362.409
R50 VDD.n668 VDD.n660 362.409
R51 VDD.n777 VDD.n774 362.409
R52 VDD.n781 VDD.n773 362.409
R53 VDD.n722 VDD.n719 362.409
R54 VDD.n726 VDD.n718 362.409
R55 VDD.t48 VDD.n581 264
R56 VDD.n535 VDD.n501 244.458
R57 VDD.n605 VDD.n468 244.458
R58 VDD.n535 VDD.n500 239.732
R59 VDD.n607 VDD.n468 239.732
R60 VDD.n533 VDD.n501 239.649
R61 VDD.n605 VDD.n467 239.649
R62 VDD.n533 VDD.n500 234.924
R63 VDD.n607 VDD.n467 234.924
R64 VDD.n597 VDD.t42 221.399
R65 VDD.t45 VDD.n595 221.399
R66 VDD.n573 VDD.n558 195.714
R67 VDD.n571 VDD.n558 192.067
R68 VDD.n330 VDD.n326 190.75
R69 VDD.n317 VDD.n309 190.75
R70 VDD.n206 VDD.n202 190.75
R71 VDD.n193 VDD.n185 190.75
R72 VDD.n254 VDD.n250 190.75
R73 VDD.n241 VDD.n233 190.75
R74 VDD.n887 VDD.n872 190.75
R75 VDD.n887 VDD.n881 190.75
R76 VDD.n903 VDD.n873 190.75
R77 VDD.n878 VDD.n873 190.75
R78 VDD.n637 VDD.n622 190.75
R79 VDD.n637 VDD.n631 190.75
R80 VDD.n653 VDD.n623 190.75
R81 VDD.n628 VDD.n623 190.75
R82 VDD.n750 VDD.n735 190.75
R83 VDD.n750 VDD.n744 190.75
R84 VDD.n766 VDD.n736 190.75
R85 VDD.n741 VDD.n736 190.75
R86 VDD.n695 VDD.n680 190.75
R87 VDD.n695 VDD.n689 190.75
R88 VDD.n711 VDD.n681 190.75
R89 VDD.n686 VDD.n681 190.75
R90 VDD.t39 VDD.t59 189.261
R91 VDD.t59 VDD.t61 189.261
R92 VDD.t63 VDD.t65 189.261
R93 VDD.t65 VDD.t57 189.261
R94 VDD.t20 VDD.t27 189.261
R95 VDD.t18 VDD.t20 189.261
R96 VDD.t22 VDD.t24 189.261
R97 VDD.t24 VDD.t30 189.261
R98 VDD.t42 VDD.t72 184.466
R99 VDD.t74 VDD.t45 184.466
R100 VDD.n535 VDD.t39 174.513
R101 VDD.t57 VDD.n533 174.513
R102 VDD.t27 VDD.n467 174.513
R103 VDD.t30 VDD.n468 174.513
R104 VDD.n450 VDD.n436 170.68
R105 VDD.n452 VDD.n436 170.68
R106 VDD.n450 VDD.n437 168.359
R107 VDD.t33 VDD.n436 163.623
R108 VDD.t36 VDD.n437 163.623
R109 VDD.n452 VDD.n437 163.387
R110 VDD.n584 VDD.n548 147.885
R111 VDD.n316 VDD.n309 135.739
R112 VDD.n329 VDD.n326 135.739
R113 VDD.n192 VDD.n185 135.739
R114 VDD.n205 VDD.n202 135.739
R115 VDD.n240 VDD.n233 135.739
R116 VDD.n253 VDD.n250 135.739
R117 VDD.n904 VDD.t114 123.112
R118 VDD.n895 VDD.t114 123.112
R119 VDD.n654 VDD.t111 123.112
R120 VDD.n645 VDD.t111 123.112
R121 VDD.n767 VDD.t91 123.112
R122 VDD.n758 VDD.t91 123.112
R123 VDD.n712 VDD.t92 123.112
R124 VDD.n703 VDD.t92 123.112
R125 VDD.n597 VDD.n543 122.684
R126 VDD.n597 VDD.n544 122.684
R127 VDD.n595 VDD.n543 122.684
R128 VDD.n595 VDD.n544 122.684
R129 VDD.n290 VDD.n168 113.275
R130 VDD.n291 VDD.n169 113.275
R131 VDD.n281 VDD.n217 113.275
R132 VDD.n282 VDD.n218 113.275
R133 VDD.n271 VDD.n265 113.275
R134 VDD.n272 VDD.n266 113.275
R135 VDD.t94 VDD.t33 106.029
R136 VDD.t96 VDD.t94 106.029
R137 VDD.t102 VDD.t96 106.029
R138 VDD.t104 VDD.t102 106.029
R139 VDD.t98 VDD.t106 106.029
R140 VDD.t106 VDD.t108 106.029
R141 VDD.t108 VDD.t100 106.029
R142 VDD.t100 VDD.t36 106.029
R143 VDD.t61 VDD.n534 105.52
R144 VDD.n606 VDD.t22 105.52
R145 VDD.n571 VDD.n560 101.463
R146 VDD.n574 VDD.n573 101.463
R147 VDD.n315 VDD.n306 96.9505
R148 VDD.n320 VDD.n306 96.9505
R149 VDD.n320 VDD.n303 96.9505
R150 VDD.n334 VDD.n303 96.9505
R151 VDD.n334 VDD.n304 96.9505
R152 VDD.n330 VDD.n304 96.9505
R153 VDD.n318 VDD.n317 96.9505
R154 VDD.n319 VDD.n318 96.9505
R155 VDD.n319 VDD.n298 96.9505
R156 VDD.n335 VDD.n298 96.9505
R157 VDD.n335 VDD.n299 96.9505
R158 VDD.n328 VDD.n299 96.9505
R159 VDD.n191 VDD.n182 96.9505
R160 VDD.n196 VDD.n182 96.9505
R161 VDD.n196 VDD.n179 96.9505
R162 VDD.n210 VDD.n179 96.9505
R163 VDD.n210 VDD.n180 96.9505
R164 VDD.n206 VDD.n180 96.9505
R165 VDD.n194 VDD.n193 96.9505
R166 VDD.n195 VDD.n194 96.9505
R167 VDD.n195 VDD.n174 96.9505
R168 VDD.n211 VDD.n174 96.9505
R169 VDD.n211 VDD.n175 96.9505
R170 VDD.n204 VDD.n175 96.9505
R171 VDD.n239 VDD.n230 96.9505
R172 VDD.n244 VDD.n230 96.9505
R173 VDD.n244 VDD.n227 96.9505
R174 VDD.n258 VDD.n227 96.9505
R175 VDD.n258 VDD.n228 96.9505
R176 VDD.n254 VDD.n228 96.9505
R177 VDD.n242 VDD.n241 96.9505
R178 VDD.n243 VDD.n242 96.9505
R179 VDD.n243 VDD.n222 96.9505
R180 VDD.n259 VDD.n222 96.9505
R181 VDD.n259 VDD.n223 96.9505
R182 VDD.n252 VDD.n223 96.9505
R183 VDD.n890 VDD.n870 96.9505
R184 VDD.n890 VDD.n882 96.9505
R185 VDD.n883 VDD.n869 96.9505
R186 VDD.n883 VDD.n879 96.9505
R187 VDD.n898 VDD.n874 96.9505
R188 VDD.n898 VDD.n897 96.9505
R189 VDD.n640 VDD.n620 96.9505
R190 VDD.n640 VDD.n632 96.9505
R191 VDD.n633 VDD.n619 96.9505
R192 VDD.n633 VDD.n629 96.9505
R193 VDD.n648 VDD.n624 96.9505
R194 VDD.n648 VDD.n647 96.9505
R195 VDD.n753 VDD.n733 96.9505
R196 VDD.n753 VDD.n745 96.9505
R197 VDD.n746 VDD.n732 96.9505
R198 VDD.n746 VDD.n742 96.9505
R199 VDD.n761 VDD.n737 96.9505
R200 VDD.n761 VDD.n760 96.9505
R201 VDD.n698 VDD.n678 96.9505
R202 VDD.n698 VDD.n690 96.9505
R203 VDD.n691 VDD.n677 96.9505
R204 VDD.n691 VDD.n687 96.9505
R205 VDD.n706 VDD.n682 96.9505
R206 VDD.n706 VDD.n705 96.9505
R207 VDD.n584 VDD.n583 96.5954
R208 VDD.n323 VDD.n304 93.8005
R209 VDD.n323 VDD.n299 93.8005
R210 VDD.n303 VDD.n302 93.8005
R211 VDD.n302 VDD.n298 93.8005
R212 VDD.n308 VDD.n306 93.8005
R213 VDD.n318 VDD.n308 93.8005
R214 VDD.n199 VDD.n180 93.8005
R215 VDD.n199 VDD.n175 93.8005
R216 VDD.n179 VDD.n178 93.8005
R217 VDD.n178 VDD.n174 93.8005
R218 VDD.n184 VDD.n182 93.8005
R219 VDD.n194 VDD.n184 93.8005
R220 VDD.n247 VDD.n228 93.8005
R221 VDD.n247 VDD.n223 93.8005
R222 VDD.n227 VDD.n226 93.8005
R223 VDD.n226 VDD.n222 93.8005
R224 VDD.n232 VDD.n230 93.8005
R225 VDD.n242 VDD.n232 93.8005
R226 VDD.n872 VDD.n870 93.8005
R227 VDD.n894 VDD.n879 93.8005
R228 VDD.n894 VDD.n882 93.8005
R229 VDD.n882 VDD.n881 93.8005
R230 VDD.n874 VDD.n871 93.8005
R231 VDD.n871 VDD.n869 93.8005
R232 VDD.n905 VDD.n869 93.8005
R233 VDD.n905 VDD.n870 93.8005
R234 VDD.n903 VDD.n874 93.8005
R235 VDD.n897 VDD.n878 93.8005
R236 VDD.n897 VDD.n896 93.8005
R237 VDD.n896 VDD.n879 93.8005
R238 VDD.n622 VDD.n620 93.8005
R239 VDD.n644 VDD.n629 93.8005
R240 VDD.n644 VDD.n632 93.8005
R241 VDD.n632 VDD.n631 93.8005
R242 VDD.n624 VDD.n621 93.8005
R243 VDD.n621 VDD.n619 93.8005
R244 VDD.n655 VDD.n619 93.8005
R245 VDD.n655 VDD.n620 93.8005
R246 VDD.n653 VDD.n624 93.8005
R247 VDD.n647 VDD.n628 93.8005
R248 VDD.n647 VDD.n646 93.8005
R249 VDD.n646 VDD.n629 93.8005
R250 VDD.n735 VDD.n733 93.8005
R251 VDD.n757 VDD.n742 93.8005
R252 VDD.n757 VDD.n745 93.8005
R253 VDD.n745 VDD.n744 93.8005
R254 VDD.n737 VDD.n734 93.8005
R255 VDD.n734 VDD.n732 93.8005
R256 VDD.n768 VDD.n732 93.8005
R257 VDD.n768 VDD.n733 93.8005
R258 VDD.n766 VDD.n737 93.8005
R259 VDD.n760 VDD.n741 93.8005
R260 VDD.n760 VDD.n759 93.8005
R261 VDD.n759 VDD.n742 93.8005
R262 VDD.n680 VDD.n678 93.8005
R263 VDD.n702 VDD.n687 93.8005
R264 VDD.n702 VDD.n690 93.8005
R265 VDD.n690 VDD.n689 93.8005
R266 VDD.n682 VDD.n679 93.8005
R267 VDD.n679 VDD.n677 93.8005
R268 VDD.n713 VDD.n677 93.8005
R269 VDD.n713 VDD.n678 93.8005
R270 VDD.n711 VDD.n682 93.8005
R271 VDD.n705 VDD.n686 93.8005
R272 VDD.n705 VDD.n704 93.8005
R273 VDD.n704 VDD.n687 93.8005
R274 VDD.t72 VDD.n596 92.2335
R275 VDD.n596 VDD.t74 92.2335
R276 VDD.n534 VDD.t63 83.7406
R277 VDD.n606 VDD.t18 83.7406
R278 VDD.n580 VDD.n551 82.34
R279 VDD.n580 VDD.n552 82.34
R280 VDD.n451 VDD.t104 68.0878
R281 VDD.n552 VDD.n549 53.8821
R282 VDD.n551 VDD.n548 53.8821
R283 VDD.n441 VDD.t35 51.7769
R284 VDD.n440 VDD.t32 51.7769
R285 VDD.n556 VDD.t54 48.2504
R286 VDD.n563 VDD.t52 48.2504
R287 VDD.n581 VDD.n550 40.8005
R288 VDD.n451 VDD.t98 37.9423
R289 VDD.n572 VDD.t2 36.8005
R290 VDD.n564 VDD.t47 30.0004
R291 VDD.n545 VDD.t50 30.0004
R292 VDD.n541 VDD.t41 30.0004
R293 VDD.n590 VDD.t44 30.0004
R294 VDD.n496 VDD.t38 22.997
R295 VDD.n503 VDD.t56 22.997
R296 VDD.n465 VDD.t29 22.997
R297 VDD.n609 VDD.t26 22.997
R298 VDD.n582 VDD.t48 15.2005
R299 VDD.n441 VDD.n440 11.066
R300 VDD.n561 VDD.t119 9.10983
R301 VDD.n527 VDD.n505 7.88616
R302 VDD.n491 VDD.n469 7.88616
R303 VDD.n527 VDD.n526 6.44616
R304 VDD.n491 VDD.n490 6.44616
R305 VDD.n509 VDD.n506 6.30761
R306 VDD.n515 VDD.n514 6.30761
R307 VDD.n475 VDD.n474 6.30761
R308 VDD.n489 VDD.n472 6.30761
R309 VDD.n512 VDD.n509 6.30642
R310 VDD.n518 VDD.n514 6.30642
R311 VDD.n478 VDD.n474 6.30642
R312 VDD.n486 VDD.n472 6.30642
R313 VDD.n568 VDD.n560 6.3005
R314 VDD.n560 VDD.n550 6.3005
R315 VDD.n575 VDD.n574 6.3005
R316 VDD.n574 VDD.n550 6.3005
R317 VDD.n463 VDD.n462 6.21365
R318 VDD.n344 VDD.n343 6.17312
R319 VDD.n525 VDD.n524 5.58761
R320 VDD.n520 VDD.n507 5.58761
R321 VDD.n517 VDD.n515 5.58761
R322 VDD.n511 VDD.n506 5.58761
R323 VDD.n481 VDD.n479 5.58761
R324 VDD.n484 VDD.n470 5.58761
R325 VDD.n489 VDD.n488 5.58761
R326 VDD.n477 VDD.n475 5.58761
R327 VDD.n524 VDD.n522 5.58642
R328 VDD.n521 VDD.n520 5.58642
R329 VDD.n518 VDD.n517 5.58642
R330 VDD.n512 VDD.n511 5.58642
R331 VDD.n482 VDD.n481 5.58642
R332 VDD.n485 VDD.n484 5.58642
R333 VDD.n488 VDD.n486 5.58642
R334 VDD.n478 VDD.n477 5.58642
R335 VDD.n560 VDD.n551 5.30576
R336 VDD.n574 VDD.n552 5.30576
R337 VDD.n538 VDD.n537 5.23945
R338 VDD.n601 VDD.n600 5.23945
R339 VDD.n459 VDD.n458 4.90112
R340 VDD.n461 VDD.n460 4.5005
R341 VDD.n428 VDD.n427 4.5005
R342 VDD.n614 VDD.n613 4.5005
R343 VDD.n613 VDD.n612 4.5005
R344 VDD.n85 VDD.n37 4.5005
R345 VDD.n865 VDD.n37 4.5005
R346 VDD.n863 VDD.n39 4.5005
R347 VDD.n85 VDD.n39 4.5005
R348 VDD.n865 VDD.n39 4.5005
R349 VDD.n863 VDD.n36 4.5005
R350 VDD.n85 VDD.n36 4.5005
R351 VDD.n865 VDD.n36 4.5005
R352 VDD.n863 VDD.n41 4.5005
R353 VDD.n85 VDD.n41 4.5005
R354 VDD.n865 VDD.n41 4.5005
R355 VDD.n863 VDD.n35 4.5005
R356 VDD.n85 VDD.n35 4.5005
R357 VDD.n865 VDD.n35 4.5005
R358 VDD.n863 VDD.n43 4.5005
R359 VDD.n85 VDD.n43 4.5005
R360 VDD.n865 VDD.n43 4.5005
R361 VDD.n863 VDD.n34 4.5005
R362 VDD.n85 VDD.n34 4.5005
R363 VDD.n865 VDD.n34 4.5005
R364 VDD.n863 VDD.n45 4.5005
R365 VDD.n85 VDD.n45 4.5005
R366 VDD.n865 VDD.n45 4.5005
R367 VDD.n863 VDD.n33 4.5005
R368 VDD.n85 VDD.n33 4.5005
R369 VDD.n865 VDD.n33 4.5005
R370 VDD.n863 VDD.n47 4.5005
R371 VDD.n85 VDD.n47 4.5005
R372 VDD.n865 VDD.n47 4.5005
R373 VDD.n863 VDD.n32 4.5005
R374 VDD.n85 VDD.n32 4.5005
R375 VDD.n865 VDD.n32 4.5005
R376 VDD.n863 VDD.n49 4.5005
R377 VDD.n85 VDD.n49 4.5005
R378 VDD.n865 VDD.n49 4.5005
R379 VDD.n863 VDD.n31 4.5005
R380 VDD.n85 VDD.n31 4.5005
R381 VDD.n865 VDD.n31 4.5005
R382 VDD.n863 VDD.n51 4.5005
R383 VDD.n85 VDD.n51 4.5005
R384 VDD.n865 VDD.n51 4.5005
R385 VDD.n863 VDD.n30 4.5005
R386 VDD.n85 VDD.n30 4.5005
R387 VDD.n865 VDD.n30 4.5005
R388 VDD.n863 VDD.n53 4.5005
R389 VDD.n85 VDD.n53 4.5005
R390 VDD.n865 VDD.n53 4.5005
R391 VDD.n863 VDD.n29 4.5005
R392 VDD.n85 VDD.n29 4.5005
R393 VDD.n865 VDD.n29 4.5005
R394 VDD.n863 VDD.n55 4.5005
R395 VDD.n85 VDD.n55 4.5005
R396 VDD.n865 VDD.n55 4.5005
R397 VDD.n863 VDD.n28 4.5005
R398 VDD.n85 VDD.n28 4.5005
R399 VDD.n865 VDD.n28 4.5005
R400 VDD.n863 VDD.n57 4.5005
R401 VDD.n85 VDD.n57 4.5005
R402 VDD.n865 VDD.n57 4.5005
R403 VDD.n863 VDD.n27 4.5005
R404 VDD.n85 VDD.n27 4.5005
R405 VDD.n865 VDD.n27 4.5005
R406 VDD.n863 VDD.n59 4.5005
R407 VDD.n85 VDD.n59 4.5005
R408 VDD.n865 VDD.n59 4.5005
R409 VDD.n863 VDD.n26 4.5005
R410 VDD.n85 VDD.n26 4.5005
R411 VDD.n865 VDD.n26 4.5005
R412 VDD.n863 VDD.n61 4.5005
R413 VDD.n85 VDD.n61 4.5005
R414 VDD.n865 VDD.n61 4.5005
R415 VDD.n863 VDD.n25 4.5005
R416 VDD.n85 VDD.n25 4.5005
R417 VDD.n865 VDD.n25 4.5005
R418 VDD.n863 VDD.n63 4.5005
R419 VDD.n85 VDD.n63 4.5005
R420 VDD.n865 VDD.n63 4.5005
R421 VDD.n863 VDD.n24 4.5005
R422 VDD.n85 VDD.n24 4.5005
R423 VDD.n865 VDD.n24 4.5005
R424 VDD.n863 VDD.n65 4.5005
R425 VDD.n85 VDD.n65 4.5005
R426 VDD.n865 VDD.n65 4.5005
R427 VDD.n863 VDD.n23 4.5005
R428 VDD.n85 VDD.n23 4.5005
R429 VDD.n865 VDD.n23 4.5005
R430 VDD.n863 VDD.n67 4.5005
R431 VDD.n85 VDD.n67 4.5005
R432 VDD.n865 VDD.n67 4.5005
R433 VDD.n863 VDD.n22 4.5005
R434 VDD.n85 VDD.n22 4.5005
R435 VDD.n865 VDD.n22 4.5005
R436 VDD.n863 VDD.n69 4.5005
R437 VDD.n85 VDD.n69 4.5005
R438 VDD.n865 VDD.n69 4.5005
R439 VDD.n863 VDD.n21 4.5005
R440 VDD.n85 VDD.n21 4.5005
R441 VDD.n865 VDD.n21 4.5005
R442 VDD.n863 VDD.n71 4.5005
R443 VDD.n85 VDD.n71 4.5005
R444 VDD.n865 VDD.n71 4.5005
R445 VDD.n863 VDD.n20 4.5005
R446 VDD.n85 VDD.n20 4.5005
R447 VDD.n865 VDD.n20 4.5005
R448 VDD.n863 VDD.n73 4.5005
R449 VDD.n85 VDD.n73 4.5005
R450 VDD.n865 VDD.n73 4.5005
R451 VDD.n863 VDD.n19 4.5005
R452 VDD.n85 VDD.n19 4.5005
R453 VDD.n865 VDD.n19 4.5005
R454 VDD.n863 VDD.n75 4.5005
R455 VDD.n85 VDD.n75 4.5005
R456 VDD.n865 VDD.n75 4.5005
R457 VDD.n863 VDD.n18 4.5005
R458 VDD.n85 VDD.n18 4.5005
R459 VDD.n865 VDD.n18 4.5005
R460 VDD.n863 VDD.n77 4.5005
R461 VDD.n85 VDD.n77 4.5005
R462 VDD.n865 VDD.n77 4.5005
R463 VDD.n863 VDD.n17 4.5005
R464 VDD.n85 VDD.n17 4.5005
R465 VDD.n865 VDD.n17 4.5005
R466 VDD.n863 VDD.n79 4.5005
R467 VDD.n85 VDD.n79 4.5005
R468 VDD.n865 VDD.n79 4.5005
R469 VDD.n863 VDD.n16 4.5005
R470 VDD.n85 VDD.n16 4.5005
R471 VDD.n865 VDD.n16 4.5005
R472 VDD.n863 VDD.n81 4.5005
R473 VDD.n85 VDD.n81 4.5005
R474 VDD.n865 VDD.n81 4.5005
R475 VDD.n863 VDD.n15 4.5005
R476 VDD.n85 VDD.n15 4.5005
R477 VDD.n865 VDD.n15 4.5005
R478 VDD.n863 VDD.n83 4.5005
R479 VDD.n85 VDD.n83 4.5005
R480 VDD.n865 VDD.n83 4.5005
R481 VDD.n863 VDD.n14 4.5005
R482 VDD.n85 VDD.n14 4.5005
R483 VDD.n865 VDD.n14 4.5005
R484 VDD.n864 VDD.n863 4.5005
R485 VDD.n865 VDD.n864 4.5005
R486 VDD.n422 VDD.n344 4.5005
R487 VDD.n422 VDD.n165 4.5005
R488 VDD.n422 VDD.n345 4.5005
R489 VDD.n422 VDD.n421 4.5005
R490 VDD.n421 VDD.n350 4.5005
R491 VDD.n347 VDD.n165 4.5005
R492 VDD.n379 VDD.n347 4.5005
R493 VDD.n376 VDD.n347 4.5005
R494 VDD.n381 VDD.n347 4.5005
R495 VDD.n375 VDD.n347 4.5005
R496 VDD.n383 VDD.n347 4.5005
R497 VDD.n374 VDD.n347 4.5005
R498 VDD.n385 VDD.n347 4.5005
R499 VDD.n373 VDD.n347 4.5005
R500 VDD.n387 VDD.n347 4.5005
R501 VDD.n372 VDD.n347 4.5005
R502 VDD.n389 VDD.n347 4.5005
R503 VDD.n371 VDD.n347 4.5005
R504 VDD.n391 VDD.n347 4.5005
R505 VDD.n370 VDD.n347 4.5005
R506 VDD.n393 VDD.n347 4.5005
R507 VDD.n369 VDD.n347 4.5005
R508 VDD.n395 VDD.n347 4.5005
R509 VDD.n368 VDD.n347 4.5005
R510 VDD.n397 VDD.n347 4.5005
R511 VDD.n367 VDD.n347 4.5005
R512 VDD.n399 VDD.n347 4.5005
R513 VDD.n366 VDD.n347 4.5005
R514 VDD.n401 VDD.n347 4.5005
R515 VDD.n365 VDD.n347 4.5005
R516 VDD.n403 VDD.n347 4.5005
R517 VDD.n364 VDD.n347 4.5005
R518 VDD.n405 VDD.n347 4.5005
R519 VDD.n363 VDD.n347 4.5005
R520 VDD.n407 VDD.n347 4.5005
R521 VDD.n362 VDD.n347 4.5005
R522 VDD.n409 VDD.n347 4.5005
R523 VDD.n361 VDD.n347 4.5005
R524 VDD.n411 VDD.n347 4.5005
R525 VDD.n360 VDD.n347 4.5005
R526 VDD.n413 VDD.n347 4.5005
R527 VDD.n359 VDD.n347 4.5005
R528 VDD.n415 VDD.n347 4.5005
R529 VDD.n358 VDD.n347 4.5005
R530 VDD.n417 VDD.n347 4.5005
R531 VDD.n357 VDD.n347 4.5005
R532 VDD.n419 VDD.n347 4.5005
R533 VDD.n356 VDD.n347 4.5005
R534 VDD.n347 VDD.n345 4.5005
R535 VDD.n421 VDD.n347 4.5005
R536 VDD.n353 VDD.n165 4.5005
R537 VDD.n379 VDD.n353 4.5005
R538 VDD.n376 VDD.n353 4.5005
R539 VDD.n381 VDD.n353 4.5005
R540 VDD.n375 VDD.n353 4.5005
R541 VDD.n383 VDD.n353 4.5005
R542 VDD.n374 VDD.n353 4.5005
R543 VDD.n385 VDD.n353 4.5005
R544 VDD.n373 VDD.n353 4.5005
R545 VDD.n387 VDD.n353 4.5005
R546 VDD.n372 VDD.n353 4.5005
R547 VDD.n389 VDD.n353 4.5005
R548 VDD.n371 VDD.n353 4.5005
R549 VDD.n391 VDD.n353 4.5005
R550 VDD.n370 VDD.n353 4.5005
R551 VDD.n393 VDD.n353 4.5005
R552 VDD.n369 VDD.n353 4.5005
R553 VDD.n395 VDD.n353 4.5005
R554 VDD.n368 VDD.n353 4.5005
R555 VDD.n397 VDD.n353 4.5005
R556 VDD.n367 VDD.n353 4.5005
R557 VDD.n399 VDD.n353 4.5005
R558 VDD.n366 VDD.n353 4.5005
R559 VDD.n401 VDD.n353 4.5005
R560 VDD.n365 VDD.n353 4.5005
R561 VDD.n403 VDD.n353 4.5005
R562 VDD.n364 VDD.n353 4.5005
R563 VDD.n405 VDD.n353 4.5005
R564 VDD.n363 VDD.n353 4.5005
R565 VDD.n407 VDD.n353 4.5005
R566 VDD.n362 VDD.n353 4.5005
R567 VDD.n409 VDD.n353 4.5005
R568 VDD.n361 VDD.n353 4.5005
R569 VDD.n411 VDD.n353 4.5005
R570 VDD.n360 VDD.n353 4.5005
R571 VDD.n413 VDD.n353 4.5005
R572 VDD.n359 VDD.n353 4.5005
R573 VDD.n415 VDD.n353 4.5005
R574 VDD.n358 VDD.n353 4.5005
R575 VDD.n417 VDD.n353 4.5005
R576 VDD.n357 VDD.n353 4.5005
R577 VDD.n419 VDD.n353 4.5005
R578 VDD.n356 VDD.n353 4.5005
R579 VDD.n353 VDD.n345 4.5005
R580 VDD.n421 VDD.n353 4.5005
R581 VDD.n346 VDD.n165 4.5005
R582 VDD.n379 VDD.n346 4.5005
R583 VDD.n376 VDD.n346 4.5005
R584 VDD.n381 VDD.n346 4.5005
R585 VDD.n375 VDD.n346 4.5005
R586 VDD.n383 VDD.n346 4.5005
R587 VDD.n374 VDD.n346 4.5005
R588 VDD.n385 VDD.n346 4.5005
R589 VDD.n373 VDD.n346 4.5005
R590 VDD.n387 VDD.n346 4.5005
R591 VDD.n372 VDD.n346 4.5005
R592 VDD.n389 VDD.n346 4.5005
R593 VDD.n371 VDD.n346 4.5005
R594 VDD.n391 VDD.n346 4.5005
R595 VDD.n370 VDD.n346 4.5005
R596 VDD.n393 VDD.n346 4.5005
R597 VDD.n369 VDD.n346 4.5005
R598 VDD.n395 VDD.n346 4.5005
R599 VDD.n368 VDD.n346 4.5005
R600 VDD.n397 VDD.n346 4.5005
R601 VDD.n367 VDD.n346 4.5005
R602 VDD.n399 VDD.n346 4.5005
R603 VDD.n366 VDD.n346 4.5005
R604 VDD.n401 VDD.n346 4.5005
R605 VDD.n365 VDD.n346 4.5005
R606 VDD.n403 VDD.n346 4.5005
R607 VDD.n364 VDD.n346 4.5005
R608 VDD.n405 VDD.n346 4.5005
R609 VDD.n363 VDD.n346 4.5005
R610 VDD.n407 VDD.n346 4.5005
R611 VDD.n362 VDD.n346 4.5005
R612 VDD.n409 VDD.n346 4.5005
R613 VDD.n361 VDD.n346 4.5005
R614 VDD.n411 VDD.n346 4.5005
R615 VDD.n360 VDD.n346 4.5005
R616 VDD.n413 VDD.n346 4.5005
R617 VDD.n359 VDD.n346 4.5005
R618 VDD.n415 VDD.n346 4.5005
R619 VDD.n358 VDD.n346 4.5005
R620 VDD.n417 VDD.n346 4.5005
R621 VDD.n357 VDD.n346 4.5005
R622 VDD.n419 VDD.n346 4.5005
R623 VDD.n356 VDD.n346 4.5005
R624 VDD.n346 VDD.n345 4.5005
R625 VDD.n421 VDD.n346 4.5005
R626 VDD.n420 VDD.n379 4.5005
R627 VDD.n420 VDD.n376 4.5005
R628 VDD.n420 VDD.n381 4.5005
R629 VDD.n420 VDD.n375 4.5005
R630 VDD.n420 VDD.n383 4.5005
R631 VDD.n420 VDD.n374 4.5005
R632 VDD.n420 VDD.n385 4.5005
R633 VDD.n420 VDD.n373 4.5005
R634 VDD.n420 VDD.n387 4.5005
R635 VDD.n420 VDD.n372 4.5005
R636 VDD.n420 VDD.n389 4.5005
R637 VDD.n420 VDD.n371 4.5005
R638 VDD.n420 VDD.n391 4.5005
R639 VDD.n420 VDD.n370 4.5005
R640 VDD.n420 VDD.n393 4.5005
R641 VDD.n420 VDD.n369 4.5005
R642 VDD.n420 VDD.n395 4.5005
R643 VDD.n420 VDD.n368 4.5005
R644 VDD.n420 VDD.n397 4.5005
R645 VDD.n420 VDD.n367 4.5005
R646 VDD.n420 VDD.n399 4.5005
R647 VDD.n420 VDD.n366 4.5005
R648 VDD.n420 VDD.n401 4.5005
R649 VDD.n420 VDD.n365 4.5005
R650 VDD.n420 VDD.n403 4.5005
R651 VDD.n420 VDD.n364 4.5005
R652 VDD.n420 VDD.n405 4.5005
R653 VDD.n420 VDD.n363 4.5005
R654 VDD.n420 VDD.n407 4.5005
R655 VDD.n420 VDD.n362 4.5005
R656 VDD.n420 VDD.n409 4.5005
R657 VDD.n420 VDD.n361 4.5005
R658 VDD.n420 VDD.n411 4.5005
R659 VDD.n420 VDD.n360 4.5005
R660 VDD.n420 VDD.n413 4.5005
R661 VDD.n420 VDD.n359 4.5005
R662 VDD.n420 VDD.n415 4.5005
R663 VDD.n420 VDD.n358 4.5005
R664 VDD.n420 VDD.n417 4.5005
R665 VDD.n420 VDD.n357 4.5005
R666 VDD.n420 VDD.n419 4.5005
R667 VDD.n420 VDD.n356 4.5005
R668 VDD.n420 VDD.n345 4.5005
R669 VDD.n421 VDD.n420 4.5005
R670 VDD.n836 VDD.n110 4.5005
R671 VDD.n836 VDD.n835 4.5005
R672 VDD.n791 VDD.n114 4.5005
R673 VDD.n114 VDD.n110 4.5005
R674 VDD.n835 VDD.n114 4.5005
R675 VDD.n791 VDD.n112 4.5005
R676 VDD.n142 VDD.n112 4.5005
R677 VDD.n793 VDD.n112 4.5005
R678 VDD.n141 VDD.n112 4.5005
R679 VDD.n795 VDD.n112 4.5005
R680 VDD.n140 VDD.n112 4.5005
R681 VDD.n797 VDD.n112 4.5005
R682 VDD.n139 VDD.n112 4.5005
R683 VDD.n799 VDD.n112 4.5005
R684 VDD.n138 VDD.n112 4.5005
R685 VDD.n801 VDD.n112 4.5005
R686 VDD.n137 VDD.n112 4.5005
R687 VDD.n803 VDD.n112 4.5005
R688 VDD.n136 VDD.n112 4.5005
R689 VDD.n805 VDD.n112 4.5005
R690 VDD.n135 VDD.n112 4.5005
R691 VDD.n807 VDD.n112 4.5005
R692 VDD.n134 VDD.n112 4.5005
R693 VDD.n809 VDD.n112 4.5005
R694 VDD.n133 VDD.n112 4.5005
R695 VDD.n811 VDD.n112 4.5005
R696 VDD.n132 VDD.n112 4.5005
R697 VDD.n813 VDD.n112 4.5005
R698 VDD.n131 VDD.n112 4.5005
R699 VDD.n815 VDD.n112 4.5005
R700 VDD.n130 VDD.n112 4.5005
R701 VDD.n817 VDD.n112 4.5005
R702 VDD.n129 VDD.n112 4.5005
R703 VDD.n819 VDD.n112 4.5005
R704 VDD.n128 VDD.n112 4.5005
R705 VDD.n821 VDD.n112 4.5005
R706 VDD.n127 VDD.n112 4.5005
R707 VDD.n823 VDD.n112 4.5005
R708 VDD.n126 VDD.n112 4.5005
R709 VDD.n825 VDD.n112 4.5005
R710 VDD.n125 VDD.n112 4.5005
R711 VDD.n827 VDD.n112 4.5005
R712 VDD.n124 VDD.n112 4.5005
R713 VDD.n829 VDD.n112 4.5005
R714 VDD.n123 VDD.n112 4.5005
R715 VDD.n831 VDD.n112 4.5005
R716 VDD.n122 VDD.n112 4.5005
R717 VDD.n833 VDD.n112 4.5005
R718 VDD.n112 VDD.n110 4.5005
R719 VDD.n835 VDD.n112 4.5005
R720 VDD.n791 VDD.n116 4.5005
R721 VDD.n142 VDD.n116 4.5005
R722 VDD.n793 VDD.n116 4.5005
R723 VDD.n141 VDD.n116 4.5005
R724 VDD.n795 VDD.n116 4.5005
R725 VDD.n140 VDD.n116 4.5005
R726 VDD.n797 VDD.n116 4.5005
R727 VDD.n139 VDD.n116 4.5005
R728 VDD.n799 VDD.n116 4.5005
R729 VDD.n138 VDD.n116 4.5005
R730 VDD.n801 VDD.n116 4.5005
R731 VDD.n137 VDD.n116 4.5005
R732 VDD.n803 VDD.n116 4.5005
R733 VDD.n136 VDD.n116 4.5005
R734 VDD.n805 VDD.n116 4.5005
R735 VDD.n135 VDD.n116 4.5005
R736 VDD.n807 VDD.n116 4.5005
R737 VDD.n134 VDD.n116 4.5005
R738 VDD.n809 VDD.n116 4.5005
R739 VDD.n133 VDD.n116 4.5005
R740 VDD.n811 VDD.n116 4.5005
R741 VDD.n132 VDD.n116 4.5005
R742 VDD.n813 VDD.n116 4.5005
R743 VDD.n131 VDD.n116 4.5005
R744 VDD.n815 VDD.n116 4.5005
R745 VDD.n130 VDD.n116 4.5005
R746 VDD.n817 VDD.n116 4.5005
R747 VDD.n129 VDD.n116 4.5005
R748 VDD.n819 VDD.n116 4.5005
R749 VDD.n128 VDD.n116 4.5005
R750 VDD.n821 VDD.n116 4.5005
R751 VDD.n127 VDD.n116 4.5005
R752 VDD.n823 VDD.n116 4.5005
R753 VDD.n126 VDD.n116 4.5005
R754 VDD.n825 VDD.n116 4.5005
R755 VDD.n125 VDD.n116 4.5005
R756 VDD.n827 VDD.n116 4.5005
R757 VDD.n124 VDD.n116 4.5005
R758 VDD.n829 VDD.n116 4.5005
R759 VDD.n123 VDD.n116 4.5005
R760 VDD.n831 VDD.n116 4.5005
R761 VDD.n122 VDD.n116 4.5005
R762 VDD.n833 VDD.n116 4.5005
R763 VDD.n116 VDD.n110 4.5005
R764 VDD.n835 VDD.n116 4.5005
R765 VDD.n791 VDD.n111 4.5005
R766 VDD.n142 VDD.n111 4.5005
R767 VDD.n793 VDD.n111 4.5005
R768 VDD.n141 VDD.n111 4.5005
R769 VDD.n795 VDD.n111 4.5005
R770 VDD.n140 VDD.n111 4.5005
R771 VDD.n797 VDD.n111 4.5005
R772 VDD.n139 VDD.n111 4.5005
R773 VDD.n799 VDD.n111 4.5005
R774 VDD.n138 VDD.n111 4.5005
R775 VDD.n801 VDD.n111 4.5005
R776 VDD.n137 VDD.n111 4.5005
R777 VDD.n803 VDD.n111 4.5005
R778 VDD.n136 VDD.n111 4.5005
R779 VDD.n805 VDD.n111 4.5005
R780 VDD.n135 VDD.n111 4.5005
R781 VDD.n807 VDD.n111 4.5005
R782 VDD.n134 VDD.n111 4.5005
R783 VDD.n809 VDD.n111 4.5005
R784 VDD.n133 VDD.n111 4.5005
R785 VDD.n811 VDD.n111 4.5005
R786 VDD.n132 VDD.n111 4.5005
R787 VDD.n813 VDD.n111 4.5005
R788 VDD.n131 VDD.n111 4.5005
R789 VDD.n815 VDD.n111 4.5005
R790 VDD.n130 VDD.n111 4.5005
R791 VDD.n817 VDD.n111 4.5005
R792 VDD.n129 VDD.n111 4.5005
R793 VDD.n819 VDD.n111 4.5005
R794 VDD.n128 VDD.n111 4.5005
R795 VDD.n821 VDD.n111 4.5005
R796 VDD.n127 VDD.n111 4.5005
R797 VDD.n823 VDD.n111 4.5005
R798 VDD.n126 VDD.n111 4.5005
R799 VDD.n825 VDD.n111 4.5005
R800 VDD.n125 VDD.n111 4.5005
R801 VDD.n827 VDD.n111 4.5005
R802 VDD.n124 VDD.n111 4.5005
R803 VDD.n829 VDD.n111 4.5005
R804 VDD.n123 VDD.n111 4.5005
R805 VDD.n831 VDD.n111 4.5005
R806 VDD.n122 VDD.n111 4.5005
R807 VDD.n833 VDD.n111 4.5005
R808 VDD.n111 VDD.n110 4.5005
R809 VDD.n835 VDD.n111 4.5005
R810 VDD.n834 VDD.n791 4.5005
R811 VDD.n834 VDD.n142 4.5005
R812 VDD.n834 VDD.n793 4.5005
R813 VDD.n834 VDD.n141 4.5005
R814 VDD.n834 VDD.n795 4.5005
R815 VDD.n834 VDD.n140 4.5005
R816 VDD.n834 VDD.n797 4.5005
R817 VDD.n834 VDD.n139 4.5005
R818 VDD.n834 VDD.n799 4.5005
R819 VDD.n834 VDD.n138 4.5005
R820 VDD.n834 VDD.n801 4.5005
R821 VDD.n834 VDD.n137 4.5005
R822 VDD.n834 VDD.n803 4.5005
R823 VDD.n834 VDD.n136 4.5005
R824 VDD.n834 VDD.n805 4.5005
R825 VDD.n834 VDD.n135 4.5005
R826 VDD.n834 VDD.n807 4.5005
R827 VDD.n834 VDD.n134 4.5005
R828 VDD.n834 VDD.n809 4.5005
R829 VDD.n834 VDD.n133 4.5005
R830 VDD.n834 VDD.n811 4.5005
R831 VDD.n834 VDD.n132 4.5005
R832 VDD.n834 VDD.n813 4.5005
R833 VDD.n834 VDD.n131 4.5005
R834 VDD.n834 VDD.n815 4.5005
R835 VDD.n834 VDD.n130 4.5005
R836 VDD.n834 VDD.n817 4.5005
R837 VDD.n834 VDD.n129 4.5005
R838 VDD.n834 VDD.n819 4.5005
R839 VDD.n834 VDD.n128 4.5005
R840 VDD.n834 VDD.n821 4.5005
R841 VDD.n834 VDD.n127 4.5005
R842 VDD.n834 VDD.n823 4.5005
R843 VDD.n834 VDD.n126 4.5005
R844 VDD.n834 VDD.n825 4.5005
R845 VDD.n834 VDD.n125 4.5005
R846 VDD.n834 VDD.n827 4.5005
R847 VDD.n834 VDD.n124 4.5005
R848 VDD.n834 VDD.n829 4.5005
R849 VDD.n834 VDD.n123 4.5005
R850 VDD.n834 VDD.n831 4.5005
R851 VDD.n834 VDD.n122 4.5005
R852 VDD.n834 VDD.n833 4.5005
R853 VDD.n835 VDD.n834 4.5005
R854 VDD.n601 VDD.t79 4.32562
R855 VDD.n314 VDD.n313 4.29115
R856 VDD.n331 VDD.n325 4.29115
R857 VDD.n190 VDD.n189 4.29115
R858 VDD.n207 VDD.n201 4.29115
R859 VDD.n238 VDD.n237 4.29115
R860 VDD.n255 VDD.n249 4.29115
R861 VDD.n889 VDD.n888 4.29115
R862 VDD.n877 VDD.n875 4.29115
R863 VDD.n639 VDD.n638 4.29115
R864 VDD.n627 VDD.n625 4.29115
R865 VDD.n752 VDD.n751 4.29115
R866 VDD.n740 VDD.n738 4.29115
R867 VDD.n697 VDD.n696 4.29115
R868 VDD.n685 VDD.n683 4.29115
R869 VDD.n313 VDD.n312 3.21763
R870 VDD.n327 VDD.n325 3.21763
R871 VDD.n189 VDD.n188 3.21763
R872 VDD.n203 VDD.n201 3.21763
R873 VDD.n237 VDD.n236 3.21763
R874 VDD.n251 VDD.n249 3.21763
R875 VDD.n888 VDD.n886 3.21763
R876 VDD.n902 VDD.n875 3.21763
R877 VDD.n638 VDD.n636 3.21763
R878 VDD.n652 VDD.n625 3.21763
R879 VDD.n751 VDD.n749 3.21763
R880 VDD.n765 VDD.n738 3.21763
R881 VDD.n696 VDD.n694 3.21763
R882 VDD.n710 VDD.n683 3.21763
R883 VDD.n536 VDD.n499 2.81655
R884 VDD.n603 VDD.n602 2.81655
R885 VDD.n570 VDD.n562 2.74432
R886 VDD.n459 VDD.t13 2.71983
R887 VDD.n458 VDD.t0 2.71983
R888 VDD.n531 VDD.n530 2.32037
R889 VDD.n494 VDD.n492 2.32037
R890 VDD.n426 VDD.n424 2.29636
R891 VDD.n600 VDD.n538 2.28366
R892 VDD.n790 VDD.n789 2.27898
R893 VDD.n463 VDD.n423 2.26477
R894 VDD.n864 VDD.n86 2.25054
R895 VDD.n348 VDD.n143 2.25054
R896 VDD.n351 VDD.n348 2.25054
R897 VDD.n354 VDD.n348 2.25054
R898 VDD.n113 VDD.n87 2.25054
R899 VDD.n120 VDD.n119 2.25054
R900 VDD.n115 VDD.n113 2.25054
R901 VDD.n120 VDD.n118 2.25054
R902 VDD.n117 VDD.n113 2.25054
R903 VDD.n862 VDD.n37 2.25053
R904 VDD.n349 VDD.n344 2.25053
R905 VDD.n352 VDD.n344 2.25053
R906 VDD.n462 VDD.n461 2.2505
R907 VDD.n38 VDD.n13 2.24748
R908 VDD.n861 VDD.n838 2.24748
R909 VDD.n40 VDD.n13 2.24748
R910 VDD.n861 VDD.n839 2.24748
R911 VDD.n42 VDD.n13 2.24748
R912 VDD.n861 VDD.n840 2.24748
R913 VDD.n44 VDD.n13 2.24748
R914 VDD.n861 VDD.n841 2.24748
R915 VDD.n46 VDD.n13 2.24748
R916 VDD.n861 VDD.n842 2.24748
R917 VDD.n48 VDD.n13 2.24748
R918 VDD.n861 VDD.n843 2.24748
R919 VDD.n50 VDD.n13 2.24748
R920 VDD.n861 VDD.n844 2.24748
R921 VDD.n52 VDD.n13 2.24748
R922 VDD.n861 VDD.n845 2.24748
R923 VDD.n54 VDD.n13 2.24748
R924 VDD.n861 VDD.n846 2.24748
R925 VDD.n56 VDD.n13 2.24748
R926 VDD.n861 VDD.n847 2.24748
R927 VDD.n58 VDD.n13 2.24748
R928 VDD.n861 VDD.n848 2.24748
R929 VDD.n60 VDD.n13 2.24748
R930 VDD.n861 VDD.n849 2.24748
R931 VDD.n62 VDD.n13 2.24748
R932 VDD.n861 VDD.n850 2.24748
R933 VDD.n64 VDD.n13 2.24748
R934 VDD.n861 VDD.n851 2.24748
R935 VDD.n66 VDD.n13 2.24748
R936 VDD.n861 VDD.n852 2.24748
R937 VDD.n68 VDD.n13 2.24748
R938 VDD.n861 VDD.n853 2.24748
R939 VDD.n70 VDD.n13 2.24748
R940 VDD.n861 VDD.n854 2.24748
R941 VDD.n72 VDD.n13 2.24748
R942 VDD.n861 VDD.n855 2.24748
R943 VDD.n74 VDD.n13 2.24748
R944 VDD.n861 VDD.n856 2.24748
R945 VDD.n76 VDD.n13 2.24748
R946 VDD.n861 VDD.n857 2.24748
R947 VDD.n78 VDD.n13 2.24748
R948 VDD.n861 VDD.n858 2.24748
R949 VDD.n80 VDD.n13 2.24748
R950 VDD.n861 VDD.n859 2.24748
R951 VDD.n82 VDD.n13 2.24748
R952 VDD.n861 VDD.n860 2.24748
R953 VDD.n84 VDD.n13 2.24748
R954 VDD.n422 VDD.n164 2.24747
R955 VDD.n422 VDD.n163 2.24747
R956 VDD.n422 VDD.n162 2.24747
R957 VDD.n422 VDD.n161 2.24747
R958 VDD.n422 VDD.n160 2.24747
R959 VDD.n422 VDD.n159 2.24747
R960 VDD.n422 VDD.n158 2.24747
R961 VDD.n422 VDD.n157 2.24747
R962 VDD.n422 VDD.n156 2.24747
R963 VDD.n422 VDD.n155 2.24747
R964 VDD.n422 VDD.n154 2.24747
R965 VDD.n422 VDD.n153 2.24747
R966 VDD.n422 VDD.n152 2.24747
R967 VDD.n422 VDD.n151 2.24747
R968 VDD.n422 VDD.n150 2.24747
R969 VDD.n422 VDD.n149 2.24747
R970 VDD.n422 VDD.n148 2.24747
R971 VDD.n422 VDD.n147 2.24747
R972 VDD.n422 VDD.n146 2.24747
R973 VDD.n422 VDD.n145 2.24747
R974 VDD.n422 VDD.n144 2.24747
R975 VDD.n378 VDD.n350 2.24747
R976 VDD.n380 VDD.n350 2.24747
R977 VDD.n382 VDD.n350 2.24747
R978 VDD.n384 VDD.n350 2.24747
R979 VDD.n386 VDD.n350 2.24747
R980 VDD.n388 VDD.n350 2.24747
R981 VDD.n390 VDD.n350 2.24747
R982 VDD.n392 VDD.n350 2.24747
R983 VDD.n394 VDD.n350 2.24747
R984 VDD.n396 VDD.n350 2.24747
R985 VDD.n398 VDD.n350 2.24747
R986 VDD.n400 VDD.n350 2.24747
R987 VDD.n402 VDD.n350 2.24747
R988 VDD.n404 VDD.n350 2.24747
R989 VDD.n406 VDD.n350 2.24747
R990 VDD.n408 VDD.n350 2.24747
R991 VDD.n410 VDD.n350 2.24747
R992 VDD.n412 VDD.n350 2.24747
R993 VDD.n414 VDD.n350 2.24747
R994 VDD.n416 VDD.n350 2.24747
R995 VDD.n418 VDD.n350 2.24747
R996 VDD.n355 VDD.n350 2.24747
R997 VDD.n420 VDD.n377 2.24747
R998 VDD.n836 VDD.n109 2.24747
R999 VDD.n836 VDD.n108 2.24747
R1000 VDD.n836 VDD.n107 2.24747
R1001 VDD.n836 VDD.n106 2.24747
R1002 VDD.n836 VDD.n105 2.24747
R1003 VDD.n836 VDD.n104 2.24747
R1004 VDD.n836 VDD.n103 2.24747
R1005 VDD.n836 VDD.n102 2.24747
R1006 VDD.n836 VDD.n101 2.24747
R1007 VDD.n836 VDD.n100 2.24747
R1008 VDD.n836 VDD.n99 2.24747
R1009 VDD.n836 VDD.n98 2.24747
R1010 VDD.n836 VDD.n97 2.24747
R1011 VDD.n836 VDD.n96 2.24747
R1012 VDD.n836 VDD.n95 2.24747
R1013 VDD.n836 VDD.n94 2.24747
R1014 VDD.n836 VDD.n93 2.24747
R1015 VDD.n836 VDD.n92 2.24747
R1016 VDD.n836 VDD.n91 2.24747
R1017 VDD.n836 VDD.n90 2.24747
R1018 VDD.n836 VDD.n89 2.24747
R1019 VDD.n836 VDD.n88 2.24747
R1020 VDD.n792 VDD.n114 2.24747
R1021 VDD.n794 VDD.n114 2.24747
R1022 VDD.n796 VDD.n114 2.24747
R1023 VDD.n798 VDD.n114 2.24747
R1024 VDD.n800 VDD.n114 2.24747
R1025 VDD.n802 VDD.n114 2.24747
R1026 VDD.n804 VDD.n114 2.24747
R1027 VDD.n806 VDD.n114 2.24747
R1028 VDD.n808 VDD.n114 2.24747
R1029 VDD.n810 VDD.n114 2.24747
R1030 VDD.n812 VDD.n114 2.24747
R1031 VDD.n814 VDD.n114 2.24747
R1032 VDD.n816 VDD.n114 2.24747
R1033 VDD.n818 VDD.n114 2.24747
R1034 VDD.n820 VDD.n114 2.24747
R1035 VDD.n822 VDD.n114 2.24747
R1036 VDD.n824 VDD.n114 2.24747
R1037 VDD.n826 VDD.n114 2.24747
R1038 VDD.n828 VDD.n114 2.24747
R1039 VDD.n830 VDD.n114 2.24747
R1040 VDD.n832 VDD.n114 2.24747
R1041 VDD.n834 VDD.n121 2.24747
R1042 VDD.n460 VDD.n429 2.23838
R1043 VDD.n427 VDD.n425 2.23803
R1044 VDD.n314 VDD.n305 2.16833
R1045 VDD.n321 VDD.n305 2.16833
R1046 VDD.n322 VDD.n321 2.16833
R1047 VDD.n333 VDD.n322 2.16833
R1048 VDD.n333 VDD.n332 2.16833
R1049 VDD.n332 VDD.n331 2.16833
R1050 VDD.n190 VDD.n181 2.16833
R1051 VDD.n197 VDD.n181 2.16833
R1052 VDD.n198 VDD.n197 2.16833
R1053 VDD.n209 VDD.n198 2.16833
R1054 VDD.n209 VDD.n208 2.16833
R1055 VDD.n208 VDD.n207 2.16833
R1056 VDD.n238 VDD.n229 2.16833
R1057 VDD.n245 VDD.n229 2.16833
R1058 VDD.n246 VDD.n245 2.16833
R1059 VDD.n257 VDD.n246 2.16833
R1060 VDD.n257 VDD.n256 2.16833
R1061 VDD.n256 VDD.n255 2.16833
R1062 VDD.n885 VDD.n884 2.16833
R1063 VDD.n892 VDD.n891 2.16833
R1064 VDD.n899 VDD.n876 2.16833
R1065 VDD.n635 VDD.n634 2.16833
R1066 VDD.n642 VDD.n641 2.16833
R1067 VDD.n649 VDD.n626 2.16833
R1068 VDD.n748 VDD.n747 2.16833
R1069 VDD.n755 VDD.n754 2.16833
R1070 VDD.n762 VDD.n739 2.16833
R1071 VDD.n693 VDD.n692 2.16833
R1072 VDD.n700 VDD.n699 2.16833
R1073 VDD.n707 VDD.n684 2.16833
R1074 VDD.n332 VDD.n324 2.12333
R1075 VDD.n322 VDD.n296 2.12333
R1076 VDD.n310 VDD.n305 2.12333
R1077 VDD.n208 VDD.n200 2.12333
R1078 VDD.n198 VDD.n172 2.12333
R1079 VDD.n186 VDD.n181 2.12333
R1080 VDD.n256 VDD.n248 2.12333
R1081 VDD.n246 VDD.n220 2.12333
R1082 VDD.n234 VDD.n229 2.12333
R1083 VDD.n880 VDD.n876 2.12333
R1084 VDD.n885 VDD.n880 2.12333
R1085 VDD.n892 VDD.n889 2.12333
R1086 VDD.n893 VDD.n885 2.12333
R1087 VDD.n893 VDD.n892 2.12333
R1088 VDD.n877 VDD.n876 2.12333
R1089 VDD.n630 VDD.n626 2.12333
R1090 VDD.n635 VDD.n630 2.12333
R1091 VDD.n642 VDD.n639 2.12333
R1092 VDD.n643 VDD.n635 2.12333
R1093 VDD.n643 VDD.n642 2.12333
R1094 VDD.n627 VDD.n626 2.12333
R1095 VDD.n743 VDD.n739 2.12333
R1096 VDD.n748 VDD.n743 2.12333
R1097 VDD.n755 VDD.n752 2.12333
R1098 VDD.n756 VDD.n748 2.12333
R1099 VDD.n756 VDD.n755 2.12333
R1100 VDD.n740 VDD.n739 2.12333
R1101 VDD.n688 VDD.n684 2.12333
R1102 VDD.n693 VDD.n688 2.12333
R1103 VDD.n700 VDD.n697 2.12333
R1104 VDD.n701 VDD.n693 2.12333
R1105 VDD.n701 VDD.n700 2.12333
R1106 VDD.n685 VDD.n684 2.12333
R1107 VDD.n324 VDD.n297 2.10963
R1108 VDD.n337 VDD.n296 2.10963
R1109 VDD.n311 VDD.n310 2.10963
R1110 VDD.n200 VDD.n173 2.10963
R1111 VDD.n213 VDD.n172 2.10963
R1112 VDD.n187 VDD.n186 2.10963
R1113 VDD.n248 VDD.n221 2.10963
R1114 VDD.n261 VDD.n220 2.10963
R1115 VDD.n235 VDD.n234 2.10963
R1116 VDD.n884 VDD.n867 2.10963
R1117 VDD.n891 VDD.n868 2.10963
R1118 VDD.n901 VDD.n899 2.10963
R1119 VDD.n634 VDD.n617 2.10963
R1120 VDD.n641 VDD.n618 2.10963
R1121 VDD.n651 VDD.n649 2.10963
R1122 VDD.n747 VDD.n730 2.10963
R1123 VDD.n754 VDD.n731 2.10963
R1124 VDD.n764 VDD.n762 2.10963
R1125 VDD.n692 VDD.n675 2.10963
R1126 VDD.n699 VDD.n676 2.10963
R1127 VDD.n709 VDD.n707 2.10963
R1128 VDD.n531 VDD.n527 2.02787
R1129 VDD.n492 VDD.n491 2.02787
R1130 VDD.n788 VDD.n787 1.94086
R1131 VDD.n564 VDD.t49 1.87444
R1132 VDD.n545 VDD.t51 1.87444
R1133 VDD.n496 VDD.t40 1.85476
R1134 VDD.n503 VDD.t58 1.85476
R1135 VDD.n465 VDD.t31 1.85476
R1136 VDD.n609 VDD.t28 1.85476
R1137 VDD.n556 VDD.t55 1.85358
R1138 VDD.n563 VDD.t53 1.85358
R1139 VDD.n608 VDD.n466 1.81826
R1140 VDD VDD.n497 1.78392
R1141 VDD.n449 VDD.n438 1.778
R1142 VDD VDD.n614 1.7669
R1143 VDD.n504 VDD.n502 1.74958
R1144 VDD.n610 VDD.n608 1.74958
R1145 VDD.n449 VDD.n448 1.70932
R1146 VDD.n530 VDD.n528 1.63418
R1147 VDD.n499 VDD.n498 1.63418
R1148 VDD.n494 VDD.n493 1.63418
R1149 VDD.n603 VDD.n495 1.63418
R1150 VDD.n615 VDD 1.59867
R1151 VDD.n593 VDD.n538 1.58497
R1152 VDD.n600 VDD.n599 1.58497
R1153 VDD.n532 VDD.n504 1.51747
R1154 VDD.n561 VDD.n559 1.48432
R1155 VDD.n612 VDD.n611 1.44455
R1156 VDD.n537 VDD.n536 1.39432
R1157 VDD.n602 VDD.n601 1.39432
R1158 VDD.n589 VDD.n588 1.35986
R1159 VDD.n554 VDD.n553 1.35867
R1160 VDD.n578 VDD.n555 1.35867
R1161 VDD.n455 VDD.n432 1.31486
R1162 VDD.n454 VDD.n433 1.31486
R1163 VDD.n435 VDD.n434 1.31486
R1164 VDD.n445 VDD.n444 1.31486
R1165 VDD.n562 VDD.n561 1.31261
R1166 VDD.n611 VDD.n464 1.20247
R1167 VDD.n570 VDD.n569 1.19063
R1168 VDD.n559 VDD.n557 1.19063
R1169 VDD.n431 VDD.t34 1.16628
R1170 VDD.n443 VDD.t37 1.16628
R1171 VDD.n540 VDD.t43 1.16628
R1172 VDD.n591 VDD.t46 1.16628
R1173 VDD.n312 VDD.n311 1.1085
R1174 VDD.n311 VDD.n295 1.1085
R1175 VDD.n337 VDD.n336 1.1085
R1176 VDD.n336 VDD.n297 1.1085
R1177 VDD.n327 VDD.n297 1.1085
R1178 VDD.n188 VDD.n187 1.1085
R1179 VDD.n187 VDD.n171 1.1085
R1180 VDD.n213 VDD.n212 1.1085
R1181 VDD.n212 VDD.n173 1.1085
R1182 VDD.n203 VDD.n173 1.1085
R1183 VDD.n236 VDD.n235 1.1085
R1184 VDD.n235 VDD.n219 1.1085
R1185 VDD.n261 VDD.n260 1.1085
R1186 VDD.n260 VDD.n221 1.1085
R1187 VDD.n251 VDD.n221 1.1085
R1188 VDD.n902 VDD.n901 1.1085
R1189 VDD.n901 VDD.n900 1.1085
R1190 VDD.n900 VDD.n867 1.1085
R1191 VDD.n906 VDD.n868 1.1085
R1192 VDD.n886 VDD.n868 1.1085
R1193 VDD.n652 VDD.n651 1.1085
R1194 VDD.n651 VDD.n650 1.1085
R1195 VDD.n650 VDD.n617 1.1085
R1196 VDD.n656 VDD.n618 1.1085
R1197 VDD.n636 VDD.n618 1.1085
R1198 VDD.n765 VDD.n764 1.1085
R1199 VDD.n764 VDD.n763 1.1085
R1200 VDD.n763 VDD.n730 1.1085
R1201 VDD.n769 VDD.n731 1.1085
R1202 VDD.n749 VDD.n731 1.1085
R1203 VDD.n710 VDD.n709 1.1085
R1204 VDD.n709 VDD.n708 1.1085
R1205 VDD.n708 VDD.n675 1.1085
R1206 VDD.n714 VDD.n676 1.1085
R1207 VDD.n694 VDD.n676 1.1085
R1208 VDD.n338 VDD.n295 1.1005
R1209 VDD.n214 VDD.n171 1.1005
R1210 VDD.n262 VDD.n219 1.1005
R1211 VDD.n907 VDD.n906 1.1005
R1212 VDD.n657 VDD.n656 1.1005
R1213 VDD.n770 VDD.n769 1.1005
R1214 VDD.n715 VDD.n714 1.1005
R1215 VDD.n791 VDD.n790 1.07139
R1216 VDD.n269 VDD.n268 1.0001
R1217 VDD.n279 VDD.n278 1.0001
R1218 VDD.n6 VDD.n3 1.0001
R1219 VDD.n665 VDD.n662 1.0001
R1220 VDD.n778 VDD.n775 1.0001
R1221 VDD.n723 VDD.n720 1.0001
R1222 VDD.n287 VDD.n286 0.995412
R1223 VDD.n269 VDD.n267 0.982368
R1224 VDD.n288 VDD.n170 0.982368
R1225 VDD.n7 VDD.n6 0.982368
R1226 VDD.n666 VDD.n665 0.982368
R1227 VDD.n779 VDD.n778 0.982368
R1228 VDD.n724 VDD.n723 0.982368
R1229 VDD.n277 VDD.n276 0.981999
R1230 VDD.n457 VDD.n430 0.9455
R1231 VDD.n447 VDD.n446 0.932105
R1232 VDD.n340 VDD.n166 0.9005
R1233 VDD.n342 VDD.n341 0.9005
R1234 VDD.n673 VDD.n616 0.9005
R1235 VDD.n672 VDD.n671 0.9005
R1236 VDD.n785 VDD.n784 0.9005
R1237 VDD.n786 VDD.n729 0.9005
R1238 VDD.n567 VDD.n554 0.881553
R1239 VDD.n578 VDD.n577 0.881553
R1240 VDD.n439 VDD.n431 0.86971
R1241 VDD.n443 VDD.n442 0.86971
R1242 VDD.n462 VDD.n424 0.8477
R1243 VDD.n594 VDD.n593 0.827079
R1244 VDD.n599 VDD.n598 0.827079
R1245 VDD.n567 VDD.n566 0.825895
R1246 VDD.n577 VDD.n576 0.825895
R1247 VDD.n268 VDD.n264 0.8233
R1248 VDD.n278 VDD.n216 0.8233
R1249 VDD.n286 VDD.n167 0.8233
R1250 VDD.n3 VDD.n0 0.8233
R1251 VDD.n662 VDD.n659 0.8233
R1252 VDD.n775 VDD.n772 0.8233
R1253 VDD.n720 VDD.n717 0.8233
R1254 VDD.n267 VDD.n264 0.805413
R1255 VDD.n276 VDD.n216 0.805413
R1256 VDD.n170 VDD.n167 0.805413
R1257 VDD.n7 VDD.n0 0.805413
R1258 VDD.n666 VDD.n659 0.805413
R1259 VDD.n779 VDD.n772 0.805413
R1260 VDD.n724 VDD.n717 0.805413
R1261 VDD.n789 VDD.n788 0.800589
R1262 VDD.n540 VDD.n539 0.782079
R1263 VDD.n592 VDD.n591 0.782079
R1264 VDD.n456 VDD.n431 0.737079
R1265 VDD.n446 VDD.n443 0.737079
R1266 VDD.n522 VDD.n512 0.7205
R1267 VDD.n522 VDD.n521 0.7205
R1268 VDD.n521 VDD.n518 0.7205
R1269 VDD.n525 VDD.n507 0.7205
R1270 VDD.n482 VDD.n478 0.7205
R1271 VDD.n485 VDD.n482 0.7205
R1272 VDD.n486 VDD.n485 0.7205
R1273 VDD.n479 VDD.n470 0.7205
R1274 VDD.n541 VDD.n540 0.708658
R1275 VDD.n591 VDD.n590 0.708658
R1276 VDD.n448 VDD.n447 0.696816
R1277 VDD.n589 VDD.n539 0.668395
R1278 VDD.n592 VDD.n589 0.668395
R1279 VDD.n458 VDD.n457 0.668055
R1280 VDD.n566 VDD.n565 0.663658
R1281 VDD.n576 VDD.n546 0.663658
R1282 VDD.n594 VDD.n587 0.663658
R1283 VDD.n598 VDD.n542 0.663658
R1284 VDD.n438 VDD.n430 0.661289
R1285 VDD.n615 VDD.n422 0.658835
R1286 VDD.n529 VDD.n499 0.586684
R1287 VDD.n604 VDD.n603 0.586684
R1288 VDD.n566 VDD.n548 0.5255
R1289 VDD.n582 VDD.n548 0.5255
R1290 VDD.n576 VDD.n549 0.5255
R1291 VDD.n595 VDD.n594 0.5255
R1292 VDD.n598 VDD.n597 0.5255
R1293 VDD.n565 VDD.n547 0.525105
R1294 VDD.n586 VDD.n546 0.525105
R1295 VDD.n783 VDD.n782 0.51934
R1296 VDD.n670 VDD.n669 0.518439
R1297 VDD.n530 VDD.n529 0.518
R1298 VDD.n604 VDD.n494 0.518
R1299 VDD.n294 VDD.n293 0.516109
R1300 VDD.n532 VDD.n531 0.496684
R1301 VDD.n492 VDD.n464 0.496684
R1302 VDD.n515 VDD.n505 0.4955
R1303 VDD.n526 VDD.n525 0.4955
R1304 VDD.n475 VDD.n469 0.4955
R1305 VDD.n490 VDD.n470 0.4955
R1306 VDD.n789 VDD.n674 0.465998
R1307 VDD.n285 VDD.n215 0.453694
R1308 VDD.n275 VDD.n263 0.453694
R1309 VDD.n728 VDD.n716 0.451068
R1310 VDD.n788 VDD.n728 0.445032
R1311 VDD.n436 VDD.n430 0.4205
R1312 VDD.n447 VDD.n437 0.4205
R1313 VDD.n589 VDD.n544 0.4205
R1314 VDD.n596 VDD.n544 0.4205
R1315 VDD.n585 VDD.n543 0.4205
R1316 VDD.n596 VDD.n543 0.4205
R1317 VDD.n11 VDD.n10 0.381569
R1318 VDD.n432 VDD.t95 0.3645
R1319 VDD.n432 VDD.t97 0.3645
R1320 VDD.n433 VDD.t103 0.3645
R1321 VDD.n433 VDD.t105 0.3645
R1322 VDD.n434 VDD.t99 0.3645
R1323 VDD.n434 VDD.t107 0.3645
R1324 VDD.n444 VDD.t109 0.3645
R1325 VDD.n444 VDD.t101 0.3645
R1326 VDD.n553 VDD.t71 0.3645
R1327 VDD.n553 VDD.t76 0.3645
R1328 VDD.n555 VDD.t77 0.3645
R1329 VDD.n555 VDD.t78 0.3645
R1330 VDD.n588 VDD.t73 0.3645
R1331 VDD.n588 VDD.t75 0.3645
R1332 VDD.n583 VDD.n582 0.343917
R1333 VDD.n790 VDD.n12 0.339947
R1334 VDD.n579 VDD.n554 0.3155
R1335 VDD.n579 VDD.n578 0.3155
R1336 VDD.n509 VDD.n508 0.3155
R1337 VDD.n524 VDD.n523 0.3155
R1338 VDD.n520 VDD.n519 0.3155
R1339 VDD.n517 VDD.n516 0.3155
R1340 VDD.n514 VDD.n513 0.3155
R1341 VDD.n511 VDD.n510 0.3155
R1342 VDD.n474 VDD.n473 0.3155
R1343 VDD.n481 VDD.n480 0.3155
R1344 VDD.n484 VDD.n483 0.3155
R1345 VDD.n488 VDD.n487 0.3155
R1346 VDD.n472 VDD.n471 0.3155
R1347 VDD.n477 VDD.n476 0.3155
R1348 VDD.n562 VDD.n558 0.3005
R1349 VDD.n580 VDD.n579 0.3005
R1350 VDD.n581 VDD.n580 0.3005
R1351 VDD.n585 VDD.n584 0.3005
R1352 VDD.n834 VDD.n615 0.297005
R1353 VDD.n302 VDD.n296 0.286864
R1354 VDD.n302 VDD.n300 0.286864
R1355 VDD.n324 VDD.n323 0.286864
R1356 VDD.n323 VDD.n301 0.286864
R1357 VDD.n310 VDD.n308 0.286864
R1358 VDD.n308 VDD.n307 0.286864
R1359 VDD.n313 VDD.n309 0.286864
R1360 VDD.n331 VDD.n330 0.286864
R1361 VDD.n330 VDD.t115 0.286864
R1362 VDD.n334 VDD.n333 0.286864
R1363 VDD.t116 VDD.n334 0.286864
R1364 VDD.n321 VDD.n320 0.286864
R1365 VDD.n320 VDD.t117 0.286864
R1366 VDD.n315 VDD.n314 0.286864
R1367 VDD.n326 VDD.n325 0.286864
R1368 VDD.n328 VDD.n327 0.286864
R1369 VDD.n336 VDD.n335 0.286864
R1370 VDD.n335 VDD.t116 0.286864
R1371 VDD.n319 VDD.n295 0.286864
R1372 VDD.t117 VDD.n319 0.286864
R1373 VDD.n317 VDD.n312 0.286864
R1374 VDD.n317 VDD.t118 0.286864
R1375 VDD.n178 VDD.n172 0.286864
R1376 VDD.n178 VDD.n176 0.286864
R1377 VDD.n200 VDD.n199 0.286864
R1378 VDD.n199 VDD.n177 0.286864
R1379 VDD.n186 VDD.n184 0.286864
R1380 VDD.n184 VDD.n183 0.286864
R1381 VDD.n189 VDD.n185 0.286864
R1382 VDD.n207 VDD.n206 0.286864
R1383 VDD.n206 VDD.t121 0.286864
R1384 VDD.n210 VDD.n209 0.286864
R1385 VDD.t122 VDD.n210 0.286864
R1386 VDD.n197 VDD.n196 0.286864
R1387 VDD.n196 VDD.t123 0.286864
R1388 VDD.n191 VDD.n190 0.286864
R1389 VDD.n202 VDD.n201 0.286864
R1390 VDD.n204 VDD.n203 0.286864
R1391 VDD.n212 VDD.n211 0.286864
R1392 VDD.n211 VDD.t122 0.286864
R1393 VDD.n195 VDD.n171 0.286864
R1394 VDD.t123 VDD.n195 0.286864
R1395 VDD.n193 VDD.n188 0.286864
R1396 VDD.n193 VDD.t124 0.286864
R1397 VDD.n226 VDD.n220 0.286864
R1398 VDD.n226 VDD.n224 0.286864
R1399 VDD.n248 VDD.n247 0.286864
R1400 VDD.n247 VDD.n225 0.286864
R1401 VDD.n234 VDD.n232 0.286864
R1402 VDD.n232 VDD.n231 0.286864
R1403 VDD.n237 VDD.n233 0.286864
R1404 VDD.n255 VDD.n254 0.286864
R1405 VDD.n254 VDD.t14 0.286864
R1406 VDD.n258 VDD.n257 0.286864
R1407 VDD.t15 VDD.n258 0.286864
R1408 VDD.n245 VDD.n244 0.286864
R1409 VDD.n244 VDD.t16 0.286864
R1410 VDD.n239 VDD.n238 0.286864
R1411 VDD.n250 VDD.n249 0.286864
R1412 VDD.n252 VDD.n251 0.286864
R1413 VDD.n260 VDD.n259 0.286864
R1414 VDD.n259 VDD.t15 0.286864
R1415 VDD.n243 VDD.n219 0.286864
R1416 VDD.t16 VDD.n243 0.286864
R1417 VDD.n241 VDD.n236 0.286864
R1418 VDD.n241 VDD.t17 0.286864
R1419 VDD.n888 VDD.n887 0.286864
R1420 VDD.n887 VDD.t114 0.286864
R1421 VDD.n894 VDD.n893 0.286864
R1422 VDD.n895 VDD.n894 0.286864
R1423 VDD.n889 VDD.n881 0.286864
R1424 VDD.n895 VDD.n881 0.286864
R1425 VDD.n891 VDD.n890 0.286864
R1426 VDD.n890 VDD.t114 0.286864
R1427 VDD.n884 VDD.n883 0.286864
R1428 VDD.n883 VDD.t114 0.286864
R1429 VDD.n896 VDD.n880 0.286864
R1430 VDD.n896 VDD.n895 0.286864
R1431 VDD.n899 VDD.n898 0.286864
R1432 VDD.n898 VDD.t114 0.286864
R1433 VDD.n878 VDD.n877 0.286864
R1434 VDD.n895 VDD.n878 0.286864
R1435 VDD.n875 VDD.n873 0.286864
R1436 VDD.n873 VDD.t114 0.286864
R1437 VDD.n903 VDD.n902 0.286864
R1438 VDD.n904 VDD.n903 0.286864
R1439 VDD.n900 VDD.n871 0.286864
R1440 VDD.n904 VDD.n871 0.286864
R1441 VDD.n906 VDD.n905 0.286864
R1442 VDD.n905 VDD.n904 0.286864
R1443 VDD.n886 VDD.n872 0.286864
R1444 VDD.n904 VDD.n872 0.286864
R1445 VDD.n638 VDD.n637 0.286864
R1446 VDD.n637 VDD.t111 0.286864
R1447 VDD.n644 VDD.n643 0.286864
R1448 VDD.n645 VDD.n644 0.286864
R1449 VDD.n639 VDD.n631 0.286864
R1450 VDD.n645 VDD.n631 0.286864
R1451 VDD.n641 VDD.n640 0.286864
R1452 VDD.n640 VDD.t111 0.286864
R1453 VDD.n634 VDD.n633 0.286864
R1454 VDD.n633 VDD.t111 0.286864
R1455 VDD.n646 VDD.n630 0.286864
R1456 VDD.n646 VDD.n645 0.286864
R1457 VDD.n649 VDD.n648 0.286864
R1458 VDD.n648 VDD.t111 0.286864
R1459 VDD.n628 VDD.n627 0.286864
R1460 VDD.n645 VDD.n628 0.286864
R1461 VDD.n625 VDD.n623 0.286864
R1462 VDD.n623 VDD.t111 0.286864
R1463 VDD.n653 VDD.n652 0.286864
R1464 VDD.n654 VDD.n653 0.286864
R1465 VDD.n650 VDD.n621 0.286864
R1466 VDD.n654 VDD.n621 0.286864
R1467 VDD.n656 VDD.n655 0.286864
R1468 VDD.n655 VDD.n654 0.286864
R1469 VDD.n636 VDD.n622 0.286864
R1470 VDD.n654 VDD.n622 0.286864
R1471 VDD.n751 VDD.n750 0.286864
R1472 VDD.n750 VDD.t91 0.286864
R1473 VDD.n757 VDD.n756 0.286864
R1474 VDD.n758 VDD.n757 0.286864
R1475 VDD.n752 VDD.n744 0.286864
R1476 VDD.n758 VDD.n744 0.286864
R1477 VDD.n754 VDD.n753 0.286864
R1478 VDD.n753 VDD.t91 0.286864
R1479 VDD.n747 VDD.n746 0.286864
R1480 VDD.n746 VDD.t91 0.286864
R1481 VDD.n759 VDD.n743 0.286864
R1482 VDD.n759 VDD.n758 0.286864
R1483 VDD.n762 VDD.n761 0.286864
R1484 VDD.n761 VDD.t91 0.286864
R1485 VDD.n741 VDD.n740 0.286864
R1486 VDD.n758 VDD.n741 0.286864
R1487 VDD.n738 VDD.n736 0.286864
R1488 VDD.n736 VDD.t91 0.286864
R1489 VDD.n766 VDD.n765 0.286864
R1490 VDD.n767 VDD.n766 0.286864
R1491 VDD.n763 VDD.n734 0.286864
R1492 VDD.n767 VDD.n734 0.286864
R1493 VDD.n769 VDD.n768 0.286864
R1494 VDD.n768 VDD.n767 0.286864
R1495 VDD.n749 VDD.n735 0.286864
R1496 VDD.n767 VDD.n735 0.286864
R1497 VDD.n696 VDD.n695 0.286864
R1498 VDD.n695 VDD.t92 0.286864
R1499 VDD.n702 VDD.n701 0.286864
R1500 VDD.n703 VDD.n702 0.286864
R1501 VDD.n697 VDD.n689 0.286864
R1502 VDD.n703 VDD.n689 0.286864
R1503 VDD.n699 VDD.n698 0.286864
R1504 VDD.n698 VDD.t92 0.286864
R1505 VDD.n692 VDD.n691 0.286864
R1506 VDD.n691 VDD.t92 0.286864
R1507 VDD.n704 VDD.n688 0.286864
R1508 VDD.n704 VDD.n703 0.286864
R1509 VDD.n707 VDD.n706 0.286864
R1510 VDD.n706 VDD.t92 0.286864
R1511 VDD.n686 VDD.n685 0.286864
R1512 VDD.n703 VDD.n686 0.286864
R1513 VDD.n683 VDD.n681 0.286864
R1514 VDD.n681 VDD.t92 0.286864
R1515 VDD.n711 VDD.n710 0.286864
R1516 VDD.n712 VDD.n711 0.286864
R1517 VDD.n708 VDD.n679 0.286864
R1518 VDD.n712 VDD.n679 0.286864
R1519 VDD.n714 VDD.n713 0.286864
R1520 VDD.n713 VDD.n712 0.286864
R1521 VDD.n694 VDD.n680 0.286864
R1522 VDD.n712 VDD.n680 0.286864
R1523 VDD.n571 VDD.n570 0.274413
R1524 VDD.n572 VDD.n571 0.274413
R1525 VDD.n573 VDD.n559 0.274413
R1526 VDD.n573 VDD.n572 0.274413
R1527 VDD.n533 VDD.n532 0.274413
R1528 VDD.n536 VDD.n535 0.274413
R1529 VDD.n467 VDD.n464 0.274413
R1530 VDD.n602 VDD.n468 0.274413
R1531 VDD.n450 VDD.n449 0.263
R1532 VDD.n451 VDD.n450 0.263
R1533 VDD.n453 VDD.n452 0.263
R1534 VDD.n452 VDD.n451 0.263
R1535 VDD.n569 VDD.n568 0.259842
R1536 VDD.n575 VDD.n557 0.259842
R1537 VDD.n270 VDD.n269 0.2525
R1538 VDD.n274 VDD.n273 0.2525
R1539 VDD.n280 VDD.n279 0.2525
R1540 VDD.n284 VDD.n283 0.2525
R1541 VDD.n289 VDD.n288 0.2525
R1542 VDD.n293 VDD.n292 0.2525
R1543 VDD.n6 VDD.n5 0.2525
R1544 VDD.n10 VDD.n9 0.2525
R1545 VDD.n665 VDD.n664 0.2525
R1546 VDD.n669 VDD.n668 0.2525
R1547 VDD.n778 VDD.n777 0.2525
R1548 VDD.n782 VDD.n781 0.2525
R1549 VDD.n723 VDD.n722 0.2525
R1550 VDD.n727 VDD.n726 0.2525
R1551 VDD.n277 VDD.n275 0.210279
R1552 VDD.n287 VDD.n285 0.210279
R1553 VDD.t115 VDD.n329 0.204778
R1554 VDD.t118 VDD.n316 0.204778
R1555 VDD.t121 VDD.n205 0.204778
R1556 VDD.t124 VDD.n192 0.204778
R1557 VDD.t14 VDD.n253 0.204778
R1558 VDD.t17 VDD.n240 0.204778
R1559 VDD.n271 VDD.n270 0.192237
R1560 VDD.n273 VDD.n272 0.192237
R1561 VDD.n281 VDD.n280 0.192237
R1562 VDD.n283 VDD.n282 0.192237
R1563 VDD.n290 VDD.n289 0.192237
R1564 VDD.n292 VDD.n291 0.192237
R1565 VDD.n502 VDD.n500 0.185794
R1566 VDD.n534 VDD.n500 0.185794
R1567 VDD.n529 VDD.n501 0.185794
R1568 VDD.n534 VDD.n501 0.185794
R1569 VDD.n605 VDD.n604 0.185794
R1570 VDD.n606 VDD.n605 0.185794
R1571 VDD.n608 VDD.n607 0.185794
R1572 VDD.n607 VDD.n606 0.185794
R1573 VDD.n528 VDD.t64 0.1825
R1574 VDD.n528 VDD.t66 0.1825
R1575 VDD.n498 VDD.t60 0.1825
R1576 VDD.n498 VDD.t62 0.1825
R1577 VDD.n493 VDD.t21 0.1825
R1578 VDD.n493 VDD.t19 0.1825
R1579 VDD.n495 VDD.t23 0.1825
R1580 VDD.n495 VDD.t25 0.1825
R1581 VDD.n583 VDD.n549 0.182439
R1582 VDD.n497 VDD.n496 0.181684
R1583 VDD.n504 VDD.n503 0.181684
R1584 VDD.n466 VDD.n465 0.181684
R1585 VDD.n610 VDD.n609 0.181684
R1586 VDD.n863 VDD.n837 0.181355
R1587 VDD.n510 VDD.t81 0.1643
R1588 VDD.n510 VDD.t82 0.1643
R1589 VDD.n508 VDD.t69 0.1643
R1590 VDD.n508 VDD.t80 0.1643
R1591 VDD.n523 VDD.t83 0.1643
R1592 VDD.n523 VDD.t84 0.1643
R1593 VDD.n519 VDD.t85 0.1643
R1594 VDD.n519 VDD.t86 0.1643
R1595 VDD.n513 VDD.t89 0.1643
R1596 VDD.n513 VDD.t67 0.1643
R1597 VDD.n516 VDD.t87 0.1643
R1598 VDD.n516 VDD.t88 0.1643
R1599 VDD.n476 VDD.t4 0.1643
R1600 VDD.n476 VDD.t5 0.1643
R1601 VDD.n473 VDD.t112 0.1643
R1602 VDD.n473 VDD.t3 0.1643
R1603 VDD.n480 VDD.t6 0.1643
R1604 VDD.n480 VDD.t7 0.1643
R1605 VDD.n483 VDD.t8 0.1643
R1606 VDD.n483 VDD.t9 0.1643
R1607 VDD.n487 VDD.t10 0.1643
R1608 VDD.n487 VDD.t11 0.1643
R1609 VDD.n471 VDD.t12 0.1643
R1610 VDD.n471 VDD.t68 0.1643
R1611 VDD.n587 VDD.n586 0.163921
R1612 VDD.n547 VDD.n542 0.163921
R1613 VDD.n611 VDD.n610 0.140758
R1614 VDD.n526 VDD.n506 0.1355
R1615 VDD.n507 VDD.n505 0.1355
R1616 VDD.n479 VDD.n469 0.1355
R1617 VDD.n490 VDD.n489 0.1355
R1618 VDD.n439 VDD.n438 0.123658
R1619 VDD.n448 VDD.n442 0.123658
R1620 VDD.n557 VDD.n556 0.123658
R1621 VDD.n565 VDD.n564 0.123658
R1622 VDD.n569 VDD.n563 0.123658
R1623 VDD.n546 VDD.n545 0.123658
R1624 VDD.n537 VDD.n497 0.123658
R1625 VDD.n599 VDD.n539 0.123658
R1626 VDD.n542 VDD.n541 0.123658
R1627 VDD.n590 VDD.n587 0.123658
R1628 VDD.n593 VDD.n592 0.123658
R1629 VDD.n601 VDD.n466 0.123658
R1630 VDD.n568 VDD.n567 0.122474
R1631 VDD.n577 VDD.n575 0.122474
R1632 VDD.n275 VDD.n274 0.107264
R1633 VDD.n285 VDD.n284 0.107264
R1634 VDD.n728 VDD.n727 0.107264
R1635 VDD.n343 VDD.n342 0.102634
R1636 VDD.n294 VDD.n166 0.101446
R1637 VDD.n585 VDD.n547 0.101043
R1638 VDD.n586 VDD.n585 0.101043
R1639 VDD.n784 VDD.n783 0.100957
R1640 VDD.n671 VDD.n670 0.100957
R1641 VDD.n674 VDD.n616 0.10071
R1642 VDD.n787 VDD.n729 0.100707
R1643 VDD.n837 VDD 0.093365
R1644 VDD.n316 VDD.n315 0.0834622
R1645 VDD.n329 VDD.n328 0.0834622
R1646 VDD.n192 VDD.n191 0.0834622
R1647 VDD.n205 VDD.n204 0.0834622
R1648 VDD.n240 VDD.n239 0.0834622
R1649 VDD.n253 VDD.n252 0.0834622
R1650 VDD.n866 VDD.n11 0.0783192
R1651 VDD.n866 VDD.n12 0.0782219
R1652 VDD.n37 VDD.n12 0.0766649
R1653 VDD.n864 VDD.n11 0.0765449
R1654 VDD.n267 VDD.n266 0.0729138
R1655 VDD.n268 VDD.n265 0.0729138
R1656 VDD.n276 VDD.n218 0.0729138
R1657 VDD.n278 VDD.n217 0.0729138
R1658 VDD.n170 VDD.n169 0.0729138
R1659 VDD.n286 VDD.n168 0.0729138
R1660 VDD.n8 VDD.n7 0.0729138
R1661 VDD.n4 VDD.n3 0.0729138
R1662 VDD.n667 VDD.n666 0.0729138
R1663 VDD.n663 VDD.n662 0.0729138
R1664 VDD.n780 VDD.n779 0.0729138
R1665 VDD.n776 VDD.n775 0.0729138
R1666 VDD.n725 VDD.n724 0.0729138
R1667 VDD.n721 VDD.n720 0.0729138
R1668 VDD.n291 VDD.t1 0.0616603
R1669 VDD.t1 VDD.n290 0.0616603
R1670 VDD.n282 VDD.t120 0.0616603
R1671 VDD.t120 VDD.n281 0.0616603
R1672 VDD.n272 VDD.t70 0.0616603
R1673 VDD.t70 VDD.n271 0.0616603
R1674 VDD VDD.n907 0.0616006
R1675 VDD.t90 VDD.n1 0.0567687
R1676 VDD.n2 VDD.t90 0.0567687
R1677 VDD.t110 VDD.n660 0.0567687
R1678 VDD.n661 VDD.t110 0.0567687
R1679 VDD.t93 VDD.n773 0.0567687
R1680 VDD.n774 VDD.t93 0.0567687
R1681 VDD.t113 VDD.n718 0.0567687
R1682 VDD.n719 VDD.t113 0.0567687
R1683 VDD.n837 VDD.n836 0.05636
R1684 VDD.n716 VDD.n715 0.0551655
R1685 VDD.n215 VDD.n214 0.0551654
R1686 VDD.n263 VDD.n262 0.0551654
R1687 VDD.n440 VDD.n439 0.0549737
R1688 VDD.n442 VDD.n441 0.0549737
R1689 VDD.n456 VDD.n455 0.0545984
R1690 VDD.n446 VDD.n445 0.0545984
R1691 VDD.n339 VDD.n338 0.0528256
R1692 VDD.n658 VDD.n657 0.0528256
R1693 VDD.n771 VDD.n770 0.0528256
R1694 VDD.n429 VDD.n425 0.0526701
R1695 VDD.n787 VDD 0.0509259
R1696 VDD.n674 VDD 0.0509225
R1697 VDD.n455 VDD.n454 0.0506639
R1698 VDD.n445 VDD.n435 0.0506639
R1699 VDD.n670 VDD.n658 0.0484805
R1700 VDD.n783 VDD.n771 0.04848
R1701 VDD.n343 VDD 0.0481409
R1702 VDD.n339 VDD.n294 0.04721
R1703 VDD.n502 VDD 0.0348421
R1704 VDD.n461 VDD.n425 0.02694
R1705 VDD.n613 VDD.n463 0.0263511
R1706 VDD.n429 VDD.n428 0.0262301
R1707 VDD.n454 VDD 0.025582
R1708 VDD.n612 VDD.n423 0.0251695
R1709 VDD.n614 VDD.n423 0.0251695
R1710 VDD.n457 VDD.n456 0.0226311
R1711 VDD.n453 VDD.n435 0.0220164
R1712 VDD.n460 VDD.n459 0.0194588
R1713 VDD.n8 VDD.n2 0.0176425
R1714 VDD.n4 VDD.n1 0.0176425
R1715 VDD.n667 VDD.n661 0.0176425
R1716 VDD.n663 VDD.n660 0.0176425
R1717 VDD.n780 VDD.n774 0.0176425
R1718 VDD.n776 VDD.n773 0.0176425
R1719 VDD.n725 VDD.n719 0.0176425
R1720 VDD.n721 VDD.n718 0.0176425
R1721 VDD.n421 VDD.n348 0.0146266
R1722 VDD.n348 VDD.n345 0.0146266
R1723 VDD.n835 VDD.n113 0.0146266
R1724 VDD.n113 VDD.n110 0.0146266
R1725 VDD.n342 VDD.n166 0.0145909
R1726 VDD.n671 VDD.n616 0.0145909
R1727 VDD.n784 VDD.n729 0.0145909
R1728 VDD.n460 VDD.n426 0.0127369
R1729 VDD.n427 VDD.n426 0.0127369
R1730 VDD.n215 VDD 0.0118606
R1731 VDD.n263 VDD 0.0118606
R1732 VDD.n716 VDD 0.0118605
R1733 VDD.n338 VDD.n337 0.0085
R1734 VDD.n214 VDD.n213 0.0085
R1735 VDD.n262 VDD.n261 0.0085
R1736 VDD.n907 VDD.n867 0.0085
R1737 VDD.n657 VDD.n617 0.0085
R1738 VDD.n770 VDD.n730 0.0085
R1739 VDD.n715 VDD.n675 0.0085
R1740 VDD.n356 VDD.n355 0.00805222
R1741 VDD.n356 VDD.n144 0.00805222
R1742 VDD.n418 VDD.n357 0.00805222
R1743 VDD.n357 VDD.n145 0.00805222
R1744 VDD.n416 VDD.n358 0.00805222
R1745 VDD.n358 VDD.n146 0.00805222
R1746 VDD.n414 VDD.n359 0.00805222
R1747 VDD.n359 VDD.n147 0.00805222
R1748 VDD.n412 VDD.n360 0.00805222
R1749 VDD.n360 VDD.n148 0.00805222
R1750 VDD.n410 VDD.n361 0.00805222
R1751 VDD.n361 VDD.n149 0.00805222
R1752 VDD.n408 VDD.n362 0.00805222
R1753 VDD.n362 VDD.n150 0.00805222
R1754 VDD.n406 VDD.n363 0.00805222
R1755 VDD.n363 VDD.n151 0.00805222
R1756 VDD.n404 VDD.n364 0.00805222
R1757 VDD.n364 VDD.n152 0.00805222
R1758 VDD.n402 VDD.n365 0.00805222
R1759 VDD.n365 VDD.n153 0.00805222
R1760 VDD.n400 VDD.n366 0.00805222
R1761 VDD.n366 VDD.n154 0.00805222
R1762 VDD.n398 VDD.n367 0.00805222
R1763 VDD.n367 VDD.n155 0.00805222
R1764 VDD.n396 VDD.n368 0.00805222
R1765 VDD.n368 VDD.n156 0.00805222
R1766 VDD.n394 VDD.n369 0.00805222
R1767 VDD.n369 VDD.n157 0.00805222
R1768 VDD.n392 VDD.n370 0.00805222
R1769 VDD.n370 VDD.n158 0.00805222
R1770 VDD.n390 VDD.n371 0.00805222
R1771 VDD.n371 VDD.n159 0.00805222
R1772 VDD.n388 VDD.n372 0.00805222
R1773 VDD.n372 VDD.n160 0.00805222
R1774 VDD.n386 VDD.n373 0.00805222
R1775 VDD.n373 VDD.n161 0.00805222
R1776 VDD.n384 VDD.n374 0.00805222
R1777 VDD.n374 VDD.n162 0.00805222
R1778 VDD.n382 VDD.n375 0.00805222
R1779 VDD.n375 VDD.n163 0.00805222
R1780 VDD.n380 VDD.n376 0.00805222
R1781 VDD.n376 VDD.n164 0.00805222
R1782 VDD.n378 VDD.n165 0.00805222
R1783 VDD.n377 VDD.n344 0.00805222
R1784 VDD.n121 VDD.n120 0.00805222
R1785 VDD.n120 VDD.n88 0.00805222
R1786 VDD.n832 VDD.n122 0.00805222
R1787 VDD.n122 VDD.n89 0.00805222
R1788 VDD.n830 VDD.n123 0.00805222
R1789 VDD.n123 VDD.n90 0.00805222
R1790 VDD.n828 VDD.n124 0.00805222
R1791 VDD.n124 VDD.n91 0.00805222
R1792 VDD.n826 VDD.n125 0.00805222
R1793 VDD.n125 VDD.n92 0.00805222
R1794 VDD.n824 VDD.n126 0.00805222
R1795 VDD.n126 VDD.n93 0.00805222
R1796 VDD.n822 VDD.n127 0.00805222
R1797 VDD.n127 VDD.n94 0.00805222
R1798 VDD.n820 VDD.n128 0.00805222
R1799 VDD.n128 VDD.n95 0.00805222
R1800 VDD.n818 VDD.n129 0.00805222
R1801 VDD.n129 VDD.n96 0.00805222
R1802 VDD.n816 VDD.n130 0.00805222
R1803 VDD.n130 VDD.n97 0.00805222
R1804 VDD.n814 VDD.n131 0.00805222
R1805 VDD.n131 VDD.n98 0.00805222
R1806 VDD.n812 VDD.n132 0.00805222
R1807 VDD.n132 VDD.n99 0.00805222
R1808 VDD.n810 VDD.n133 0.00805222
R1809 VDD.n133 VDD.n100 0.00805222
R1810 VDD.n808 VDD.n134 0.00805222
R1811 VDD.n134 VDD.n101 0.00805222
R1812 VDD.n806 VDD.n135 0.00805222
R1813 VDD.n135 VDD.n102 0.00805222
R1814 VDD.n804 VDD.n136 0.00805222
R1815 VDD.n136 VDD.n103 0.00805222
R1816 VDD.n802 VDD.n137 0.00805222
R1817 VDD.n137 VDD.n104 0.00805222
R1818 VDD.n800 VDD.n138 0.00805222
R1819 VDD.n138 VDD.n105 0.00805222
R1820 VDD.n798 VDD.n139 0.00805222
R1821 VDD.n139 VDD.n106 0.00805222
R1822 VDD.n796 VDD.n140 0.00805222
R1823 VDD.n140 VDD.n107 0.00805222
R1824 VDD.n794 VDD.n141 0.00805222
R1825 VDD.n141 VDD.n108 0.00805222
R1826 VDD.n792 VDD.n142 0.00805222
R1827 VDD.n142 VDD.n109 0.00805222
R1828 VDD.n379 VDD.n164 0.00805222
R1829 VDD.n381 VDD.n163 0.00805222
R1830 VDD.n383 VDD.n162 0.00805222
R1831 VDD.n385 VDD.n161 0.00805222
R1832 VDD.n387 VDD.n160 0.00805222
R1833 VDD.n389 VDD.n159 0.00805222
R1834 VDD.n391 VDD.n158 0.00805222
R1835 VDD.n393 VDD.n157 0.00805222
R1836 VDD.n395 VDD.n156 0.00805222
R1837 VDD.n397 VDD.n155 0.00805222
R1838 VDD.n399 VDD.n154 0.00805222
R1839 VDD.n401 VDD.n153 0.00805222
R1840 VDD.n403 VDD.n152 0.00805222
R1841 VDD.n405 VDD.n151 0.00805222
R1842 VDD.n407 VDD.n150 0.00805222
R1843 VDD.n409 VDD.n149 0.00805222
R1844 VDD.n411 VDD.n148 0.00805222
R1845 VDD.n413 VDD.n147 0.00805222
R1846 VDD.n415 VDD.n146 0.00805222
R1847 VDD.n417 VDD.n145 0.00805222
R1848 VDD.n419 VDD.n144 0.00805222
R1849 VDD.n379 VDD.n378 0.00805222
R1850 VDD.n381 VDD.n380 0.00805222
R1851 VDD.n383 VDD.n382 0.00805222
R1852 VDD.n385 VDD.n384 0.00805222
R1853 VDD.n387 VDD.n386 0.00805222
R1854 VDD.n389 VDD.n388 0.00805222
R1855 VDD.n391 VDD.n390 0.00805222
R1856 VDD.n393 VDD.n392 0.00805222
R1857 VDD.n395 VDD.n394 0.00805222
R1858 VDD.n397 VDD.n396 0.00805222
R1859 VDD.n399 VDD.n398 0.00805222
R1860 VDD.n401 VDD.n400 0.00805222
R1861 VDD.n403 VDD.n402 0.00805222
R1862 VDD.n405 VDD.n404 0.00805222
R1863 VDD.n407 VDD.n406 0.00805222
R1864 VDD.n409 VDD.n408 0.00805222
R1865 VDD.n411 VDD.n410 0.00805222
R1866 VDD.n413 VDD.n412 0.00805222
R1867 VDD.n415 VDD.n414 0.00805222
R1868 VDD.n417 VDD.n416 0.00805222
R1869 VDD.n419 VDD.n418 0.00805222
R1870 VDD.n355 VDD.n345 0.00805222
R1871 VDD.n377 VDD.n165 0.00805222
R1872 VDD.n791 VDD.n109 0.00805222
R1873 VDD.n793 VDD.n108 0.00805222
R1874 VDD.n795 VDD.n107 0.00805222
R1875 VDD.n797 VDD.n106 0.00805222
R1876 VDD.n799 VDD.n105 0.00805222
R1877 VDD.n801 VDD.n104 0.00805222
R1878 VDD.n803 VDD.n103 0.00805222
R1879 VDD.n805 VDD.n102 0.00805222
R1880 VDD.n807 VDD.n101 0.00805222
R1881 VDD.n809 VDD.n100 0.00805222
R1882 VDD.n811 VDD.n99 0.00805222
R1883 VDD.n813 VDD.n98 0.00805222
R1884 VDD.n815 VDD.n97 0.00805222
R1885 VDD.n817 VDD.n96 0.00805222
R1886 VDD.n819 VDD.n95 0.00805222
R1887 VDD.n821 VDD.n94 0.00805222
R1888 VDD.n823 VDD.n93 0.00805222
R1889 VDD.n825 VDD.n92 0.00805222
R1890 VDD.n827 VDD.n91 0.00805222
R1891 VDD.n829 VDD.n90 0.00805222
R1892 VDD.n831 VDD.n89 0.00805222
R1893 VDD.n833 VDD.n88 0.00805222
R1894 VDD.n793 VDD.n792 0.00805222
R1895 VDD.n795 VDD.n794 0.00805222
R1896 VDD.n797 VDD.n796 0.00805222
R1897 VDD.n799 VDD.n798 0.00805222
R1898 VDD.n801 VDD.n800 0.00805222
R1899 VDD.n803 VDD.n802 0.00805222
R1900 VDD.n805 VDD.n804 0.00805222
R1901 VDD.n807 VDD.n806 0.00805222
R1902 VDD.n809 VDD.n808 0.00805222
R1903 VDD.n811 VDD.n810 0.00805222
R1904 VDD.n813 VDD.n812 0.00805222
R1905 VDD.n815 VDD.n814 0.00805222
R1906 VDD.n817 VDD.n816 0.00805222
R1907 VDD.n819 VDD.n818 0.00805222
R1908 VDD.n821 VDD.n820 0.00805222
R1909 VDD.n823 VDD.n822 0.00805222
R1910 VDD.n825 VDD.n824 0.00805222
R1911 VDD.n827 VDD.n826 0.00805222
R1912 VDD.n829 VDD.n828 0.00805222
R1913 VDD.n831 VDD.n830 0.00805222
R1914 VDD.n833 VDD.n832 0.00805222
R1915 VDD.n121 VDD.n110 0.00805222
R1916 VDD.n84 VDD.n14 0.00803444
R1917 VDD.n860 VDD.n83 0.00803444
R1918 VDD.n82 VDD.n15 0.00803444
R1919 VDD.n859 VDD.n81 0.00803444
R1920 VDD.n80 VDD.n16 0.00803444
R1921 VDD.n858 VDD.n79 0.00803444
R1922 VDD.n78 VDD.n17 0.00803444
R1923 VDD.n857 VDD.n77 0.00803444
R1924 VDD.n76 VDD.n18 0.00803444
R1925 VDD.n856 VDD.n75 0.00803444
R1926 VDD.n74 VDD.n19 0.00803444
R1927 VDD.n855 VDD.n73 0.00803444
R1928 VDD.n72 VDD.n20 0.00803444
R1929 VDD.n854 VDD.n71 0.00803444
R1930 VDD.n70 VDD.n21 0.00803444
R1931 VDD.n853 VDD.n69 0.00803444
R1932 VDD.n68 VDD.n22 0.00803444
R1933 VDD.n852 VDD.n67 0.00803444
R1934 VDD.n66 VDD.n23 0.00803444
R1935 VDD.n851 VDD.n65 0.00803444
R1936 VDD.n64 VDD.n24 0.00803444
R1937 VDD.n850 VDD.n63 0.00803444
R1938 VDD.n62 VDD.n25 0.00803444
R1939 VDD.n849 VDD.n61 0.00803444
R1940 VDD.n60 VDD.n26 0.00803444
R1941 VDD.n848 VDD.n59 0.00803444
R1942 VDD.n58 VDD.n27 0.00803444
R1943 VDD.n847 VDD.n57 0.00803444
R1944 VDD.n56 VDD.n28 0.00803444
R1945 VDD.n846 VDD.n55 0.00803444
R1946 VDD.n54 VDD.n29 0.00803444
R1947 VDD.n845 VDD.n53 0.00803444
R1948 VDD.n52 VDD.n30 0.00803444
R1949 VDD.n844 VDD.n51 0.00803444
R1950 VDD.n50 VDD.n31 0.00803444
R1951 VDD.n843 VDD.n49 0.00803444
R1952 VDD.n48 VDD.n32 0.00803444
R1953 VDD.n842 VDD.n47 0.00803444
R1954 VDD.n46 VDD.n33 0.00803444
R1955 VDD.n841 VDD.n45 0.00803444
R1956 VDD.n44 VDD.n34 0.00803444
R1957 VDD.n840 VDD.n43 0.00803444
R1958 VDD.n42 VDD.n35 0.00803444
R1959 VDD.n839 VDD.n41 0.00803444
R1960 VDD.n40 VDD.n36 0.00803444
R1961 VDD.n838 VDD.n39 0.00803444
R1962 VDD.n38 VDD.n37 0.00803444
R1963 VDD.n39 VDD.n38 0.00803444
R1964 VDD.n838 VDD.n36 0.00803444
R1965 VDD.n41 VDD.n40 0.00803444
R1966 VDD.n839 VDD.n35 0.00803444
R1967 VDD.n43 VDD.n42 0.00803444
R1968 VDD.n840 VDD.n34 0.00803444
R1969 VDD.n45 VDD.n44 0.00803444
R1970 VDD.n841 VDD.n33 0.00803444
R1971 VDD.n47 VDD.n46 0.00803444
R1972 VDD.n842 VDD.n32 0.00803444
R1973 VDD.n49 VDD.n48 0.00803444
R1974 VDD.n843 VDD.n31 0.00803444
R1975 VDD.n51 VDD.n50 0.00803444
R1976 VDD.n844 VDD.n30 0.00803444
R1977 VDD.n53 VDD.n52 0.00803444
R1978 VDD.n845 VDD.n29 0.00803444
R1979 VDD.n55 VDD.n54 0.00803444
R1980 VDD.n846 VDD.n28 0.00803444
R1981 VDD.n57 VDD.n56 0.00803444
R1982 VDD.n847 VDD.n27 0.00803444
R1983 VDD.n59 VDD.n58 0.00803444
R1984 VDD.n848 VDD.n26 0.00803444
R1985 VDD.n61 VDD.n60 0.00803444
R1986 VDD.n849 VDD.n25 0.00803444
R1987 VDD.n63 VDD.n62 0.00803444
R1988 VDD.n850 VDD.n24 0.00803444
R1989 VDD.n65 VDD.n64 0.00803444
R1990 VDD.n851 VDD.n23 0.00803444
R1991 VDD.n67 VDD.n66 0.00803444
R1992 VDD.n852 VDD.n22 0.00803444
R1993 VDD.n69 VDD.n68 0.00803444
R1994 VDD.n853 VDD.n21 0.00803444
R1995 VDD.n71 VDD.n70 0.00803444
R1996 VDD.n854 VDD.n20 0.00803444
R1997 VDD.n73 VDD.n72 0.00803444
R1998 VDD.n855 VDD.n19 0.00803444
R1999 VDD.n75 VDD.n74 0.00803444
R2000 VDD.n856 VDD.n18 0.00803444
R2001 VDD.n77 VDD.n76 0.00803444
R2002 VDD.n857 VDD.n17 0.00803444
R2003 VDD.n79 VDD.n78 0.00803444
R2004 VDD.n858 VDD.n16 0.00803444
R2005 VDD.n81 VDD.n80 0.00803444
R2006 VDD.n859 VDD.n15 0.00803444
R2007 VDD.n83 VDD.n82 0.00803444
R2008 VDD.n860 VDD.n14 0.00803444
R2009 VDD.n864 VDD.n84 0.00803444
R2010 VDD.n673 VDD.n672 0.00729659
R2011 VDD.n786 VDD.n785 0.00729659
R2012 VDD.n341 VDD.n340 0.00705699
R2013 VDD.n288 VDD.n287 0.00518493
R2014 VDD VDD.n453 0.00406557
R2015 VDD.n672 VDD.n658 0.00378867
R2016 VDD.n785 VDD.n771 0.00378867
R2017 VDD.n866 VDD.n865 0.00377
R2018 VDD.n340 VDD.n339 0.00367274
R2019 VDD VDD.n866 0.003065
R2020 VDD.n85 VDD.n13 0.00236
R2021 VDD.n865 VDD.n13 0.00236
R2022 VDD.n861 VDD.n86 0.00192981
R2023 VDD.n86 VDD.n85 0.00192981
R2024 VDD.n114 VDD.n87 0.00192981
R2025 VDD.n119 VDD.n112 0.00192981
R2026 VDD.n116 VDD.n115 0.00192981
R2027 VDD.n118 VDD.n111 0.00192981
R2028 VDD.n834 VDD.n117 0.00192981
R2029 VDD.n350 VDD.n143 0.00192981
R2030 VDD.n353 VDD.n351 0.00192981
R2031 VDD.n420 VDD.n354 0.00192981
R2032 VDD.n422 VDD.n143 0.00192981
R2033 VDD.n351 VDD.n347 0.00192981
R2034 VDD.n354 VDD.n346 0.00192981
R2035 VDD.n836 VDD.n87 0.00192981
R2036 VDD.n119 VDD.n114 0.00192981
R2037 VDD.n115 VDD.n112 0.00192981
R2038 VDD.n118 VDD.n116 0.00192981
R2039 VDD.n117 VDD.n111 0.00192981
R2040 VDD.n862 VDD.n861 0.00192981
R2041 VDD.n863 VDD.n862 0.00192981
R2042 VDD.n349 VDD.n347 0.00192981
R2043 VDD.n352 VDD.n346 0.00192981
R2044 VDD.n350 VDD.n349 0.00192981
R2045 VDD.n353 VDD.n352 0.00192981
R2046 VDD.n274 VDD.n264 0.00162836
R2047 VDD.n284 VDD.n216 0.00162836
R2048 VDD.n293 VDD.n167 0.00162836
R2049 VDD.n10 VDD.n0 0.00162836
R2050 VDD.n669 VDD.n659 0.00162836
R2051 VDD.n782 VDD.n772 0.00162836
R2052 VDD.n727 VDD.n717 0.00162836
R2053 VDD VDD.n673 0.00159622
R2054 VDD VDD.n786 0.00159622
R2055 VDD.n341 VDD 0.00155758
R2056 VDD.n428 VDD.n424 0.000978723
R2057 VDD.n279 VDD.n277 0.000869863
R2058 VSS.n1300 VSS.n649 88097
R2059 VSS.n1051 VSS.n1050 63819
R2060 VSS.n926 VSS.n884 53926
R2061 VSS.n1558 VSS.n1557 52356
R2062 VSS.n1555 VSS.n610 51475.4
R2063 VSS.n1051 VSS.n884 40107.6
R2064 VSS.n1559 VSS.n1558 36701.2
R2065 VSS.n1206 VSS.n679 28495.8
R2066 VSS.n1052 VSS.n1051 28251.4
R2067 VSS.n1207 VSS.t12 19746.5
R2068 VSS.n1050 VSS.n885 19278.6
R2069 VSS.n886 VSS.n885 15810.8
R2070 VSS.n1206 VSS.t2 15492.6
R2071 VSS.n733 VSS.t286 15492.6
R2072 VSS.n1808 VSS.n1807 14167.8
R2073 VSS.n1049 VSS.n679 12085.6
R2074 VSS.n1474 VSS.n649 11433.2
R2075 VSS.n1457 VSS.n649 8945.79
R2076 VSS.t308 VSS.n926 8612.37
R2077 VSS.n1205 VSS.n679 8109.39
R2078 VSS.n1460 VSS.n649 6802.62
R2079 VSS.n1457 VSS.n678 6801.23
R2080 VSS.n1807 VSS.t12 6392.64
R2081 VSS.n1052 VSS.n679 5264.97
R2082 VSS.n423 VSS.n119 4431.82
R2083 VSS.n1456 VSS.t311 4363.2
R2084 VSS.n1807 VSS.n102 3992.32
R2085 VSS.n1460 VSS.n1459 3817.76
R2086 VSS.n1557 VSS.n1556 3549.57
R2087 VSS.t288 VSS.n1206 3494.43
R2088 VSS.n774 VSS.n679 3479.27
R2089 VSS.n1461 VSS.n1460 3131.02
R2090 VSS.t210 VSS.t290 2825.51
R2091 VSS.n1302 VSS.n1292 2482.49
R2092 VSS.n1455 VSS.n1454 2482.2
R2093 VSS.n1302 VSS.n1300 2353.54
R2094 VSS.n1302 VSS.n1301 2282.65
R2095 VSS.n1456 VSS.n1455 2238.42
R2096 VSS.n1207 VSS.t288 2106.63
R2097 VSS.t2 VSS.n1205 2060.8
R2098 VSS.n1808 VSS.t286 2060.8
R2099 VSS.n356 VSS.n119 2022.77
R2100 VSS.n886 VSS.n884 1944.69
R2101 VSS.n1557 VSS.n423 1891.78
R2102 VSS.n1461 VSS.n610 1884.83
R2103 VSS.n1559 VSS.n356 1854.19
R2104 VSS.n1797 VSS.n1796 1406.54
R2105 VSS.n1560 VSS.n112 1406.54
R2106 VSS.n1458 VSS.n1457 1247.7
R2107 VSS.n1456 VSS.n679 1221.62
R2108 VSS.n424 VSS.n423 1214.8
R2109 VSS.n1293 VSS.n678 1214.8
R2110 VSS.n1462 VSS.n1461 1214.8
R2111 VSS.n887 VSS.n886 1214.8
R2112 VSS.n1304 VSS.n119 1129.14
R2113 VSS.n925 VSS.n924 1082.66
R2114 VSS.t192 VSS.t285 993.824
R2115 VSS.n609 VSS.n608 982.105
R2116 VSS.n1457 VSS.n1456 967.711
R2117 VSS.n1455 VSS.n680 860.186
R2118 VSS.t259 VSS.n691 819.861
R2119 VSS.n1797 VSS.n102 813.727
R2120 VSS.n1796 VSS.n112 813.727
R2121 VSS.t210 VSS.n682 804.263
R2122 VSS.n1806 VSS.n105 766.962
R2123 VSS.t210 VSS.t289 760.088
R2124 VSS.t307 VSS.t289 760.088
R2125 VSS.t280 VSS.t285 760.088
R2126 VSS.t255 VSS.t0 760.088
R2127 VSS.t256 VSS.t0 760.088
R2128 VSS.t257 VSS.t256 760.088
R2129 VSS.n1560 VSS.n1559 701.79
R2130 VSS.n1805 VSS.n106 569.333
R2131 VSS.n1795 VSS.n113 569.333
R2132 VSS.n608 VSS.n424 569.333
R2133 VSS.n1561 VSS.n421 569.333
R2134 VSS.n1453 VSS.n1293 569.333
R2135 VSS.n1048 VSS.n887 569.333
R2136 VSS.n1462 VSS.n676 569.333
R2137 VSS.n788 VSS.n776 563.697
R2138 VSS.n1556 VSS.n609 516.606
R2139 VSS.t308 VSS.n924 448.332
R2140 VSS.t311 VSS.n677 448.332
R2141 VSS.n764 VSS.n758 441.514
R2142 VSS.n1053 VSS.n883 434.945
R2143 VSS.n609 VSS.n119 426.286
R2144 VSS.n926 VSS.n925 396.509
R2145 VSS.n105 VSS.n104 352.88
R2146 VSS.t302 VSS.n1303 330.509
R2147 VSS.t302 VSS.n1304 330.509
R2148 VSS.n1818 VSS.n98 293.539
R2149 VSS.n1818 VSS.n99 293.539
R2150 VSS.n1816 VSS.n99 293.539
R2151 VSS.n1816 VSS.n98 293.539
R2152 VSS.n1197 VSS.n772 293.539
R2153 VSS.n1197 VSS.n773 293.539
R2154 VSS.n1195 VSS.n773 293.539
R2155 VSS.n1195 VSS.n772 293.539
R2156 VSS.n1190 VSS.n781 272.724
R2157 VSS.n1190 VSS.n1101 272.724
R2158 VSS.n1303 VSS.n1302 244.327
R2159 VSS.n758 VSS.t12 240.826
R2160 VSS.n1243 VSS.n88 240.119
R2161 VSS.n1151 VSS.n1112 240.119
R2162 VSS.n1827 VSS.n88 235.513
R2163 VSS.n1151 VSS.n1111 235.513
R2164 VSS.n1276 VSS.n719 225.659
R2165 VSS.n1276 VSS.n696 225.659
R2166 VSS.n1829 VSS.n81 225.659
R2167 VSS.n1829 VSS.n83 225.659
R2168 VSS.n829 VSS.n817 225.659
R2169 VSS.n817 VSS.n794 225.659
R2170 VSS.t309 VSS.n912 216.887
R2171 VSS.n1010 VSS.t311 216.887
R2172 VSS.t308 VSS.n912 216.887
R2173 VSS.t310 VSS.n1010 216.887
R2174 VSS.t310 VSS.n906 216.887
R2175 VSS.n1748 VSS.n1739 213.5
R2176 VSS.n1747 VSS.n1739 213.5
R2177 VSS.n1789 VSS.n118 213.5
R2178 VSS.n1789 VSS.n117 213.5
R2179 VSS.n1448 VSS.n1298 213.5
R2180 VSS.n1448 VSS.n1299 213.5
R2181 VSS.n1447 VSS.n1309 213.5
R2182 VSS.n1447 VSS.n1308 213.5
R2183 VSS.n603 VSS.n429 213.5
R2184 VSS.n603 VSS.n602 213.5
R2185 VSS.n470 VSS.n455 213.5
R2186 VSS.n476 VSS.n455 213.5
R2187 VSS.n1567 VSS.n406 213.5
R2188 VSS.n1566 VSS.n406 213.5
R2189 VSS.n416 VSS.n414 213.5
R2190 VSS.n416 VSS.n413 213.5
R2191 VSS.n671 VSS.n644 213.5
R2192 VSS.n671 VSS.n612 213.5
R2193 VSS.n1553 VSS.n614 213.5
R2194 VSS.n1473 VSS.n614 213.5
R2195 VSS.n1043 VSS.n892 213.5
R2196 VSS.n1043 VSS.n1042 213.5
R2197 VSS.n944 VSS.n923 213.5
R2198 VSS.n945 VSS.n923 213.5
R2199 VSS.n184 VSS.n182 213.5
R2200 VSS.n185 VSS.n182 213.5
R2201 VSS.n1799 VSS.n110 213.5
R2202 VSS.n1799 VSS.n111 213.5
R2203 VSS.n1798 VSS.n1797 209.923
R2204 VSS.n1740 VSS.n112 209.923
R2205 VSS.n1206 VSS.t290 208.929
R2206 VSS.t257 VSS.n733 208.929
R2207 VSS.n1788 VSS.t319 205.519
R2208 VSS.t319 VSS.n1787 205.519
R2209 VSS.n1787 VSS.t318 205.519
R2210 VSS.n127 VSS.t318 205.519
R2211 VSS.t317 VSS.n127 205.519
R2212 VSS.t317 VSS.n128 205.519
R2213 VSS.t316 VSS.n128 205.519
R2214 VSS.t316 VSS.n1740 205.519
R2215 VSS.t315 VSS.n183 205.519
R2216 VSS.t315 VSS.n175 205.519
R2217 VSS.t314 VSS.n175 205.519
R2218 VSS.t314 VSS.n176 205.519
R2219 VSS.t313 VSS.n176 205.519
R2220 VSS.t313 VSS.n192 205.519
R2221 VSS.n192 VSS.t312 205.519
R2222 VSS.n1798 VSS.t312 205.519
R2223 VSS.n1555 VSS.n1554 202.333
R2224 VSS.n1474 VSS.t306 199.472
R2225 VSS.n1554 VSS.t306 199.472
R2226 VSS.n1234 VSS.n749 195.725
R2227 VSS.n1234 VSS.n86 195.725
R2228 VSS.n1143 VSS.n1139 195.725
R2229 VSS.n1144 VSS.n1143 195.725
R2230 VSS.n1104 VSS.n781 194.066
R2231 VSS.n1106 VSS.n1101 194.066
R2232 VSS.n1556 VSS.n1555 190.518
R2233 VSS.n906 VSS.n885 186.376
R2234 VSS.t280 VSS.n691 173.964
R2235 VSS.n1053 VSS.t271 171.329
R2236 VSS.n925 VSS.n610 170.524
R2237 VSS.n1263 VSS.n1246 169.29
R2238 VSS.n1246 VSS.n65 169.29
R2239 VSS.n734 VSS.n65 169.29
R2240 VSS.n1263 VSS.n734 169.29
R2241 VSS.n59 VSS.n56 169.29
R2242 VSS.n59 VSS.n57 169.29
R2243 VSS.n1876 VSS.n57 169.29
R2244 VSS.n1876 VSS.n56 169.29
R2245 VSS.n864 VSS.n816 169.29
R2246 VSS.n819 VSS.n816 169.29
R2247 VSS.n819 VSS.n815 169.29
R2248 VSS.n864 VSS.n815 169.29
R2249 VSS.n1454 VSS.n1292 165.442
R2250 VSS.t271 VSS.n1052 164.436
R2251 VSS.n1220 VSS.n762 163.488
R2252 VSS.n1220 VSS.n763 163.488
R2253 VSS.n1218 VSS.n763 163.488
R2254 VSS.n1218 VSS.n762 163.488
R2255 VSS.n1187 VSS.n1105 157.225
R2256 VSS.n695 VSS.n692 155.013
R2257 VSS.n1281 VSS.n695 155.013
R2258 VSS.n1852 VSS.n82 155.013
R2259 VSS.n1850 VSS.n82 155.013
R2260 VSS.n831 VSS.n795 155.013
R2261 VSS.n877 VSS.n795 155.013
R2262 VSS.n1232 VSS.n751 154.554
R2263 VSS.n1232 VSS.n89 154.554
R2264 VSS.n1125 VSS.n1120 154.554
R2265 VSS.n1125 VSS.n1119 154.554
R2266 VSS.n1187 VSS.n1108 152.619
R2267 VSS.n415 VSS.t284 142.47
R2268 VSS.t284 VSS.n346 142.47
R2269 VSS.t283 VSS.n346 142.47
R2270 VSS.t283 VSS.n347 142.47
R2271 VSS.n719 VSS.n692 141.29
R2272 VSS.n1281 VSS.n696 141.29
R2273 VSS.n1852 VSS.n81 141.29
R2274 VSS.n1850 VSS.n83 141.29
R2275 VSS.n409 VSS.n357 139.917
R2276 VSS.t281 VSS.t301 139.917
R2277 VSS.n422 VSS.n410 139.917
R2278 VSS.n1090 VSS.n1064 135.488
R2279 VSS.n1077 VSS.n1064 135.488
R2280 VSS.n1077 VSS.n1063 135.488
R2281 VSS.n1090 VSS.n1063 135.488
R2282 VSS.t30 VSS.n774 134.022
R2283 VSS.n1266 VSS.n720 132.079
R2284 VSS.n1266 VSS.n730 132.079
R2285 VSS.n747 VSS.n725 132.079
R2286 VSS.n1273 VSS.n725 132.079
R2287 VSS.n1866 VSS.n60 132.079
R2288 VSS.n1866 VSS.n74 132.079
R2289 VSS.n1832 VSS.n61 132.079
R2290 VSS.n1873 VSS.n61 132.079
R2291 VSS.n860 VSS.n820 132.079
R2292 VSS.n857 VSS.n820 132.079
R2293 VSS.n870 VSS.n869 132.079
R2294 VSS.n870 VSS.n808 132.079
R2295 VSS.n1109 VSS.t72 128.75
R2296 VSS.n356 VSS.n347 122.427
R2297 VSS.n1558 VSS.n422 121.662
R2298 VSS.n948 VSS.n912 115.96
R2299 VSS.n1010 VSS.n1009 115.96
R2300 VSS.t261 VSS.t30 114.445
R2301 VSS.t262 VSS.t261 114.445
R2302 VSS.t263 VSS.t262 114.445
R2303 VSS.t264 VSS.t265 114.445
R2304 VSS.t267 VSS.t268 114.445
R2305 VSS.t268 VSS.t269 114.445
R2306 VSS.n1807 VSS.n1806 109.829
R2307 VSS.n121 VSS.n118 108.501
R2308 VSS.n1782 VSS.n121 108.501
R2309 VSS.n1782 VSS.n1781 108.501
R2310 VSS.n1781 VSS.n1780 108.501
R2311 VSS.n1780 VSS.n125 108.501
R2312 VSS.n1747 VSS.n125 108.501
R2313 VSS.n120 VSS.n117 108.501
R2314 VSS.n1699 VSS.n120 108.501
R2315 VSS.n1699 VSS.n129 108.501
R2316 VSS.n1779 VSS.n129 108.501
R2317 VSS.n1779 VSS.n130 108.501
R2318 VSS.n1748 VSS.n130 108.501
R2319 VSS.n1343 VSS.n1305 108.501
R2320 VSS.n1385 VSS.n1305 108.501
R2321 VSS.n1342 VSS.n1306 108.501
R2322 VSS.n1384 VSS.n1306 108.501
R2323 VSS.n1337 VSS.n1307 108.501
R2324 VSS.n1382 VSS.n1307 108.501
R2325 VSS.n555 VSS.n554 108.501
R2326 VSS.n555 VSS.n430 108.501
R2327 VSS.n549 VSS.n440 108.501
R2328 VSS.n549 VSS.n548 108.501
R2329 VSS.n478 VSS.n477 108.501
R2330 VSS.n478 VSS.n444 108.501
R2331 VSS.n414 VSS.n349 108.501
R2332 VSS.n1603 VSS.n349 108.501
R2333 VSS.n1603 VSS.n350 108.501
R2334 VSS.n1599 VSS.n350 108.501
R2335 VSS.n1599 VSS.n355 108.501
R2336 VSS.n1566 VSS.n355 108.501
R2337 VSS.n413 VSS.n344 108.501
R2338 VSS.n1604 VSS.n344 108.501
R2339 VSS.n1604 VSS.n345 108.501
R2340 VSS.n1598 VSS.n345 108.501
R2341 VSS.n1598 VSS.n358 108.501
R2342 VSS.n1567 VSS.n358 108.501
R2343 VSS.n1478 VSS.n1476 108.501
R2344 VSS.n1478 VSS.n1477 108.501
R2345 VSS.n647 VSS.n646 108.501
R2346 VSS.n646 VSS.n645 108.501
R2347 VSS.n1467 VSS.n651 108.501
R2348 VSS.n1467 VSS.n615 108.501
R2349 VSS.n1009 VSS.n908 108.501
R2350 VSS.n1009 VSS.n893 108.501
R2351 VSS.n1003 VSS.n1002 108.501
R2352 VSS.n1003 VSS.n905 108.501
R2353 VSS.n948 VSS.n911 108.501
R2354 VSS.n948 VSS.n913 108.501
R2355 VSS.n184 VSS.n173 108.501
R2356 VSS.n277 VSS.n173 108.501
R2357 VSS.n277 VSS.n174 108.501
R2358 VSS.n271 VSS.n174 108.501
R2359 VSS.n271 VSS.n193 108.501
R2360 VSS.n193 VSS.n110 108.501
R2361 VSS.n185 VSS.n178 108.501
R2362 VSS.n276 VSS.n178 108.501
R2363 VSS.n276 VSS.n179 108.501
R2364 VSS.n272 VSS.n179 108.501
R2365 VSS.n272 VSS.n191 108.501
R2366 VSS.n191 VSS.n111 108.501
R2367 VSS.n1003 VSS.n906 107.204
R2368 VSS.n188 VSS.n174 105.001
R2369 VSS.n188 VSS.n179 105.001
R2370 VSS.n1786 VSS.n120 105.001
R2371 VSS.n1786 VSS.n121 105.001
R2372 VSS.n129 VSS.n124 105.001
R2373 VSS.n1781 VSS.n124 105.001
R2374 VSS.n1741 VSS.n130 105.001
R2375 VSS.n1741 VSS.n125 105.001
R2376 VSS.n1343 VSS.n1298 105.001
R2377 VSS.n1386 VSS.n1384 105.001
R2378 VSS.n1386 VSS.n1385 105.001
R2379 VSS.n1385 VSS.n1299 105.001
R2380 VSS.n1341 VSS.n1337 105.001
R2381 VSS.n1342 VSS.n1341 105.001
R2382 VSS.n1344 VSS.n1342 105.001
R2383 VSS.n1344 VSS.n1343 105.001
R2384 VSS.n1382 VSS.n1309 105.001
R2385 VSS.n1383 VSS.n1382 105.001
R2386 VSS.n1384 VSS.n1383 105.001
R2387 VSS.n1337 VSS.n1308 105.001
R2388 VSS.n554 VSS.n429 105.001
R2389 VSS.n548 VSS.n443 105.001
R2390 VSS.n443 VSS.n430 105.001
R2391 VSS.n602 VSS.n430 105.001
R2392 VSS.n477 VSS.n454 105.001
R2393 VSS.n454 VSS.n440 105.001
R2394 VSS.n553 VSS.n440 105.001
R2395 VSS.n554 VSS.n553 105.001
R2396 VSS.n470 VSS.n444 105.001
R2397 VSS.n547 VSS.n444 105.001
R2398 VSS.n548 VSS.n547 105.001
R2399 VSS.n477 VSS.n476 105.001
R2400 VSS.n348 VSS.n344 105.001
R2401 VSS.n349 VSS.n348 105.001
R2402 VSS.n352 VSS.n345 105.001
R2403 VSS.n352 VSS.n350 105.001
R2404 VSS.n408 VSS.n358 105.001
R2405 VSS.n408 VSS.n355 105.001
R2406 VSS.n1476 VSS.n644 105.001
R2407 VSS.n645 VSS.n613 105.001
R2408 VSS.n1477 VSS.n613 105.001
R2409 VSS.n1477 VSS.n612 105.001
R2410 VSS.n651 VSS.n650 105.001
R2411 VSS.n650 VSS.n647 105.001
R2412 VSS.n1475 VSS.n647 105.001
R2413 VSS.n1476 VSS.n1475 105.001
R2414 VSS.n1553 VSS.n615 105.001
R2415 VSS.n615 VSS.n611 105.001
R2416 VSS.n645 VSS.n611 105.001
R2417 VSS.n1473 VSS.n651 105.001
R2418 VSS.n908 VSS.n892 105.001
R2419 VSS.n1011 VSS.n905 105.001
R2420 VSS.n1011 VSS.n893 105.001
R2421 VSS.n1042 VSS.n893 105.001
R2422 VSS.n1001 VSS.n911 105.001
R2423 VSS.n1002 VSS.n1001 105.001
R2424 VSS.n1002 VSS.n907 105.001
R2425 VSS.n908 VSS.n907 105.001
R2426 VSS.n944 VSS.n913 105.001
R2427 VSS.n1000 VSS.n913 105.001
R2428 VSS.n1000 VSS.n905 105.001
R2429 VSS.n945 VSS.n911 105.001
R2430 VSS.n177 VSS.n173 105.001
R2431 VSS.n178 VSS.n177 105.001
R2432 VSS.n234 VSS.n193 105.001
R2433 VSS.n234 VSS.n191 105.001
R2434 VSS.t219 VSS.t221 98.823
R2435 VSS.t225 VSS.t66 98.823
R2436 VSS.t228 VSS.t235 98.823
R2437 VSS.t237 VSS.t230 98.823
R2438 VSS.t230 VSS.t69 98.823
R2439 VSS.t241 VSS.t243 98.823
R2440 VSS.t243 VSS.t233 98.823
R2441 VSS.n1050 VSS.n1049 96.3497
R2442 VSS.n733 VSS.t12 93.8204
R2443 VSS.n1827 VSS.n89 83.2637
R2444 VSS.n1243 VSS.n751 83.2637
R2445 VSS.n1120 VSS.n1111 83.2637
R2446 VSS.n1119 VSS.n1112 83.2637
R2447 VSS.n1105 VSS.n1104 83.2637
R2448 VSS.n1108 VSS.n1106 83.2637
R2449 VSS.n883 VSS.t105 82.1213
R2450 VSS.t87 VSS.n764 82.1213
R2451 VSS.t75 VSS.t228 81.3837
R2452 VSS.t211 VSS.t54 76.7988
R2453 VSS.t215 VSS.t217 76.7988
R2454 VSS.n776 VSS.t267 76.4224
R2455 VSS.n1097 VSS.n1060 75.2505
R2456 VSS.n1093 VSS.n1060 75.2505
R2457 VSS.n1093 VSS.n1059 75.2505
R2458 VSS.n1097 VSS.n1059 75.2505
R2459 VSS.n1285 VSS.n690 75.2505
R2460 VSS.n1081 VSS.n690 75.2505
R2461 VSS.n1081 VSS.n689 75.2505
R2462 VSS.n1285 VSS.n689 75.2505
R2463 VSS.n732 VSS.n726 73.4084
R2464 VSS.n735 VSS.n732 73.4084
R2465 VSS.n1868 VSS.n62 73.4084
R2466 VSS.n1868 VSS.n69 73.4084
R2467 VSS.n862 VSS.n861 73.4084
R2468 VSS.n862 VSS.n809 73.4084
R2469 VSS.n1104 VSS.n1103 71.6584
R2470 VSS.n1106 VSS.n1103 71.6584
R2471 VSS.t105 VSS.t272 70.1261
R2472 VSS.t272 VSS.t276 70.1261
R2473 VSS.t278 VSS.t274 70.1261
R2474 VSS.t274 VSS.t87 70.1261
R2475 VSS.t221 VSS.t199 69.7575
R2476 VSS.t213 VSS.n1152 67.3873
R2477 VSS.t169 VSS.t72 67.0108
R2478 VSS.t22 VSS.n793 63.3916
R2479 VSS.t17 VSS.n858 63.3916
R2480 VSS.n824 VSS.t45 61.3194
R2481 VSS.n806 VSS.t48 61.3194
R2482 VSS.n728 VSS.t114 61.3194
R2483 VSS.n75 VSS.t122 61.3194
R2484 VSS.n1252 VSS.t139 61.3194
R2485 VSS.n722 VSS.t116 61.3194
R2486 VSS.t195 VSS.n1109 60.9874
R2487 VSS.n1138 VSS.n775 60.3136
R2488 VSS.n681 VSS.t290 58.9532
R2489 VSS.n747 VSS.n735 58.6716
R2490 VSS.n735 VSS.n730 58.6716
R2491 VSS.n1273 VSS.n726 58.6716
R2492 VSS.n726 VSS.n720 58.6716
R2493 VSS.n1832 VSS.n69 58.6716
R2494 VSS.n74 VSS.n69 58.6716
R2495 VSS.n1873 VSS.n62 58.6716
R2496 VSS.n62 VSS.n60 58.6716
R2497 VSS.n869 VSS.n809 58.6716
R2498 VSS.n857 VSS.n809 58.6716
R2499 VSS.n861 VSS.n808 58.6716
R2500 VSS.n861 VSS.n860 58.6716
R2501 VSS.t169 VSS.t264 58.3522
R2502 VSS.n1196 VSS.t265 57.2228
R2503 VSS.n1196 VSS.t266 57.2228
R2504 VSS.n1300 VSS.n678 56.8622
R2505 VSS.t169 VSS.t263 56.0934
R2506 VSS.t54 VSS.t195 54.2111
R2507 VSS.n1283 VSS.n691 52.8144
R2508 VSS.t63 VSS.t22 52.021
R2509 VSS.n1154 VSS.t68 51.6309
R2510 VSS.n1168 VSS.t65 51.6309
R2511 VSS.n824 VSS.t16 51.6309
R2512 VSS.n806 VSS.t51 51.6309
R2513 VSS.n728 VSS.t112 51.6309
R2514 VSS.n75 VSS.t120 51.6309
R2515 VSS.n1252 VSS.t141 51.6309
R2516 VSS.n722 VSS.t118 51.6309
R2517 VSS.t178 VSS.t49 50.8839
R2518 VSS.t223 VSS.n1110 49.4117
R2519 VSS.n1110 VSS.t225 49.4117
R2520 VSS.n1107 VSS.t241 49.4117
R2521 VSS.n1130 VSS.t42 48.1738
R2522 VSS.n100 VSS.t163 48.1738
R2523 VSS.n1201 VSS.t29 48.1727
R2524 VSS.n1811 VSS.t166 48.1727
R2525 VSS.t259 VSS.n1083 44.212
R2526 VSS.t255 VSS.t100 42.03
R2527 VSS.n89 VSS.n86 41.1716
R2528 VSS.n751 VSS.n749 41.1716
R2529 VSS.n1139 VSS.n1120 41.1716
R2530 VSS.n1144 VSS.n1119 41.1716
R2531 VSS.t235 VSS.n1102 40.6921
R2532 VSS.t1 VSS.t211 39.529
R2533 VSS.n1099 VSS.t192 38.8445
R2534 VSS.t190 VSS.t203 38.6554
R2535 VSS.t207 VSS.t191 38.6554
R2536 VSS.n1107 VSS.n682 38.27
R2537 VSS.t60 VSS.t17 37.8077
R2538 VSS.n1828 VSS.n87 37.6583
R2539 VSS.n1188 VSS.t237 37.3011
R2540 VSS.n777 VSS.t270 36.9403
R2541 VSS.n777 VSS.t43 36.6716
R2542 VSS.t174 VSS.t46 36.6707
R2543 VSS.n868 VSS.t4 36.1021
R2544 VSS.n859 VSS.t170 36.1021
R2545 VSS.n1219 VSS.t276 35.0633
R2546 VSS.n1219 VSS.t278 35.0633
R2547 VSS.n1100 VSS.t307 34.3604
R2548 VSS.t266 VSS.t169 33.5057
R2549 VSS.n838 VSS.t36 33.4124
R2550 VSS.n835 VSS.t32 33.4124
R2551 VSS.n799 VSS.t34 33.4124
R2552 VSS.n802 VSS.t24 33.4124
R2553 VSS.n1856 VSS.t149 33.4124
R2554 VSS.n1859 VSS.t147 33.4124
R2555 VSS.n1844 VSS.t124 33.4124
R2556 VSS.n1841 VSS.t152 33.4124
R2557 VSS.n701 VSS.t95 33.4124
R2558 VSS.n704 VSS.t92 33.4124
R2559 VSS.n713 VSS.t97 33.4124
R2560 VSS.n710 VSS.t89 33.4124
R2561 VSS.n804 VSS.t40 33.2585
R2562 VSS.n826 VSS.t21 33.2585
R2563 VSS.n828 VSS.t19 33.2585
R2564 VSS.n840 VSS.t38 33.2585
R2565 VSS.n708 VSS.t26 33.2585
R2566 VSS.n715 VSS.t99 33.2585
R2567 VSS.n1839 VSS.t127 33.2585
R2568 VSS.n1846 VSS.t136 33.2585
R2569 VSS.n1861 VSS.t145 33.2585
R2570 VSS.n80 VSS.t161 33.2585
R2571 VSS.n706 VSS.t102 33.2585
R2572 VSS.n698 VSS.t81 33.2585
R2573 VSS.t169 VSS.n777 33.1734
R2574 VSS.t8 VSS.t219 33.047
R2575 VSS.t305 VSS.t49 32.9752
R2576 VSS.t305 VSS.t46 32.9752
R2577 VSS.n748 VSS.t257 32.8265
R2578 VSS.n1098 VSS.t6 31.4459
R2579 VSS.n1301 VSS.n119 30.7011
R2580 VSS.t309 VSS.n885 30.5124
R2581 VSS.n1067 VSS.t13 29.9227
R2582 VSS.n1068 VSS.t83 29.9227
R2583 VSS.n760 VSS.t86 29.9227
R2584 VSS.n766 VSS.t104 29.9227
R2585 VSS.n1274 VSS.t256 29.912
R2586 VSS.t199 VSS.t223 29.0659
R2587 VSS.n863 VSS.t173 28.9955
R2588 VSS.n863 VSS.t172 28.9955
R2589 VSS.n104 VSS.t167 27.3043
R2590 VSS.n850 VSS.t62 26.1657
R2591 VSS.n851 VSS.t59 26.1657
R2592 VSS.n1879 VSS.t133 26.1657
R2593 VSS.n1257 VSS.t110 26.1657
R2594 VSS.n1258 VSS.t107 26.1657
R2595 VSS.n1880 VSS.t143 26.1657
R2596 VSS.n780 VSS.t56 26.1219
R2597 VSS.n1192 VSS.t53 26.1219
R2598 VSS.n1459 VSS.n677 25.7113
R2599 VSS.t108 VSS.t131 25.0035
R2600 VSS.n879 VSS.n793 23.5945
R2601 VSS.n858 VSS.n791 23.5945
R2602 VSS.t9 VSS.n119 23.3928
R2603 VSS.t164 VSS.t291 23.3161
R2604 VSS.t291 VSS.t292 23.3161
R2605 VSS.t293 VSS.t294 23.3161
R2606 VSS.t298 VSS.t297 23.3161
R2607 VSS.t299 VSS.t298 23.3161
R2608 VSS.t300 VSS.t299 23.3161
R2609 VSS.t167 VSS.t300 23.3161
R2610 VSS.n1459 VSS.n1458 23.2255
R2611 VSS.t155 VSS.t253 22.4725
R2612 VSS.t4 VSS.t180 22.4574
R2613 VSS.n868 VSS.t5 21.8889
R2614 VSS.n859 VSS.t171 21.8889
R2615 VSS.t307 VSS.n1099 21.3296
R2616 VSS.t172 VSS.t174 21.3204
R2617 VSS.n1275 VSS.n1274 21.1686
R2618 VSS.n1831 VSS.n1830 21.1686
R2619 VSS.t193 VSS.t285 21.0152
R2620 VSS.t280 VSS.t201 21.0152
R2621 VSS.t10 VSS.t256 20.7085
R2622 VSS.t150 VSS.t293 20.4784
R2623 VSS.t171 VSS.t60 20.1833
R2624 VSS.t282 VSS.n356 20.0433
R2625 VSS.t1 VSS.t7 19.2001
R2626 VSS.n1804 VSS.n1803 19.0974
R2627 VSS.n1794 VSS.n1793 19.0974
R2628 VSS.n607 VSS.n425 19.0974
R2629 VSS.n1562 VSS.n420 19.0974
R2630 VSS.n1452 VSS.n1294 19.0974
R2631 VSS.n1047 VSS.n888 19.0974
R2632 VSS.n1463 VSS.n675 19.0974
R2633 VSS.n775 VSS.n773 18.2444
R2634 VSS.n1091 VSS.t304 18.1008
R2635 VSS.n694 VSS.t254 18.1008
R2636 VSS.t7 VSS.t213 18.0707
R2637 VSS.t217 VSS.t8 18.0707
R2638 VSS.n1792 VSS.n114 17.9357
R2639 VSS.n606 VSS.n426 17.9357
R2640 VSS.n1563 VSS.n419 17.9357
R2641 VSS.n1451 VSS.n1295 17.9357
R2642 VSS.n1046 VSS.n889 17.9357
R2643 VSS.n1464 VSS.n674 17.9357
R2644 VSS.n1802 VSS.n107 17.9357
R2645 VSS.t66 VSS.t75 17.4398
R2646 VSS.n87 VSS.t125 17.4105
R2647 VSS.t297 VSS.n103 17.3338
R2648 VSS.t131 VSS.t134 16.8737
R2649 VSS.t305 VSS.t176 16.7721
R2650 VSS.n1264 VSS.t257 16.7203
R2651 VSS.t69 VSS.t290 16.4709
R2652 VSS.n1092 VSS.n1091 16.1834
R2653 VSS.n1083 VSS.t255 15.9621
R2654 VSS.n1100 VSS.t305 15.8766
R2655 VSS.t247 VSS.t249 15.6465
R2656 VSS.t249 VSS.t251 15.6465
R2657 VSS.t209 VSS.t0 15.1096
R2658 VSS.n1265 VSS.n1264 14.4961
R2659 VSS.n1851 VSS.t294 14.4961
R2660 VSS.n1275 VSS.t0 14.266
R2661 VSS.n1282 VSS.n694 13.8058
R2662 VSS.n91 VSS.t159 13.5593
R2663 VSS.n754 VSS.t157 13.5593
R2664 VSS.n1121 VSS.t77 13.5593
R2665 VSS.n1114 VSS.t79 13.5593
R2666 VSS.n1875 VSS.n58 12.3486
R2667 VSS.n1189 VSS.n1188 12.1111
R2668 VSS.t305 VSS.n879 11.9396
R2669 VSS.t305 VSS.n791 11.9396
R2670 VSS.n1788 VSS.n119 11.7865
R2671 VSS.n183 VSS.n105 11.7865
R2672 VSS.n1072 VSS.t193 11.6583
R2673 VSS.n1817 VSS.t295 11.6583
R2674 VSS.n1817 VSS.t296 11.6583
R2675 VSS.n731 VSS.t10 11.1981
R2676 VSS.t11 VSS.n73 11.1981
R2677 VSS.n1092 VSS.t14 11.1214
R2678 VSS.n1284 VSS.t84 11.1214
R2679 VSS.t169 VSS.t269 10.9179
R2680 VSS.n1291 VSS.t247 10.8914
R2681 VSS.n1225 VSS.n1224 10.8653
R2682 VSS.n851 VSS.n850 10.7105
R2683 VSS.n1258 VSS.n1257 10.7105
R2684 VSS.n1880 VSS.n1879 10.7105
R2685 VSS.n1056 VSS.n1055 10.4478
R2686 VSS.n1073 VSS.n1072 10.3545
R2687 VSS.t210 VSS.t245 10.2778
R2688 VSS.t169 VSS.n775 10.1964
R2689 VSS.n1168 VSS.n1154 10.148
R2690 VSS.n1208 VSS.n1207 10.1308
R2691 VSS.n1233 VSS.n1230 9.971
R2692 VSS.t125 VSS.t164 9.8943
R2693 VSS.n1152 VSS.t215 9.41206
R2694 VSS.n1230 VSS.t190 9.35743
R2695 VSS.n1134 VSS.t71 8.98167
R2696 VSS.n1229 VSS.t154 8.98167
R2697 VSS.n1236 VSS.t130 8.98167
R2698 VSS.n1141 VSS.t74 8.98167
R2699 VSS.n1244 VSS.n750 8.89726
R2700 VSS.n1189 VSS.n1102 8.72013
R2701 VSS.n85 VSS.t207 8.28369
R2702 VSS.t170 VSS.t176 8.24418
R2703 VSS.t100 VSS.t209 8.20699
R2704 VSS.t253 VSS.t137 8.20699
R2705 VSS.n415 VSS.n119 8.17082
R2706 VSS.t251 VSS.t289 8.13029
R2707 VSS.n682 VSS.n681 7.97689
R2708 VSS.n1082 VSS.t90 7.90021
R2709 VSS.t295 VSS.t128 7.74681
R2710 VSS.t305 VSS.t57 7.59342
R2711 VSS.t57 VSS.t289 7.51672
R2712 VSS.t173 VSS.t178 7.10712
R2713 VSS.n1830 VSS.t155 6.90315
R2714 VSS.n1245 VSS.n748 6.82646
R2715 VSS.n1875 VSS.n1874 6.82646
R2716 VSS.n103 VSS.t296 5.9828
R2717 VSS.t5 VSS.t63 5.97006
R2718 VSS.n754 VSS.n91 5.71885
R2719 VSS.n1121 VSS.n1114 5.71885
R2720 VSS.n1193 VSS.n779 4.88557
R2721 VSS.n786 VSS.t58 4.8305
R2722 VSS.t55 VSS.n1159 4.8305
R2723 VSS.t245 VSS.n1291 4.75566
R2724 VSS.n1937 VSS.n22 4.5005
R2725 VSS.n1937 VSS.n23 4.5005
R2726 VSS.n1907 VSS.n23 4.5005
R2727 VSS.n1909 VSS.n23 4.5005
R2728 VSS.n1935 VSS.n23 4.5005
R2729 VSS.n1910 VSS.n1909 4.5005
R2730 VSS.n1935 VSS.n1910 4.5005
R2731 VSS.n1937 VSS.n24 4.5005
R2732 VSS.n47 VSS.n24 4.5005
R2733 VSS.n1909 VSS.n24 4.5005
R2734 VSS.n1935 VSS.n24 4.5005
R2735 VSS.n1937 VSS.n21 4.5005
R2736 VSS.n47 VSS.n21 4.5005
R2737 VSS.n1909 VSS.n21 4.5005
R2738 VSS.n1935 VSS.n21 4.5005
R2739 VSS.n1937 VSS.n25 4.5005
R2740 VSS.n47 VSS.n25 4.5005
R2741 VSS.n1909 VSS.n25 4.5005
R2742 VSS.n1935 VSS.n25 4.5005
R2743 VSS.n1937 VSS.n20 4.5005
R2744 VSS.n47 VSS.n20 4.5005
R2745 VSS.n1909 VSS.n20 4.5005
R2746 VSS.n1935 VSS.n20 4.5005
R2747 VSS.n1937 VSS.n26 4.5005
R2748 VSS.n47 VSS.n26 4.5005
R2749 VSS.n1909 VSS.n26 4.5005
R2750 VSS.n1935 VSS.n26 4.5005
R2751 VSS.n1937 VSS.n19 4.5005
R2752 VSS.n47 VSS.n19 4.5005
R2753 VSS.n1909 VSS.n19 4.5005
R2754 VSS.n1935 VSS.n19 4.5005
R2755 VSS.n1937 VSS.n27 4.5005
R2756 VSS.n47 VSS.n27 4.5005
R2757 VSS.n1909 VSS.n27 4.5005
R2758 VSS.n1935 VSS.n27 4.5005
R2759 VSS.n1937 VSS.n18 4.5005
R2760 VSS.n47 VSS.n18 4.5005
R2761 VSS.n1909 VSS.n18 4.5005
R2762 VSS.n1935 VSS.n18 4.5005
R2763 VSS.n1937 VSS.n28 4.5005
R2764 VSS.n47 VSS.n28 4.5005
R2765 VSS.n1909 VSS.n28 4.5005
R2766 VSS.n1935 VSS.n28 4.5005
R2767 VSS.n1937 VSS.n17 4.5005
R2768 VSS.n47 VSS.n17 4.5005
R2769 VSS.n1909 VSS.n17 4.5005
R2770 VSS.n1935 VSS.n17 4.5005
R2771 VSS.n1937 VSS.n29 4.5005
R2772 VSS.n47 VSS.n29 4.5005
R2773 VSS.n1909 VSS.n29 4.5005
R2774 VSS.n1935 VSS.n29 4.5005
R2775 VSS.n1937 VSS.n16 4.5005
R2776 VSS.n47 VSS.n16 4.5005
R2777 VSS.n1909 VSS.n16 4.5005
R2778 VSS.n1935 VSS.n16 4.5005
R2779 VSS.n1937 VSS.n30 4.5005
R2780 VSS.n47 VSS.n30 4.5005
R2781 VSS.n1909 VSS.n30 4.5005
R2782 VSS.n1935 VSS.n30 4.5005
R2783 VSS.n1937 VSS.n15 4.5005
R2784 VSS.n47 VSS.n15 4.5005
R2785 VSS.n1909 VSS.n15 4.5005
R2786 VSS.n1935 VSS.n15 4.5005
R2787 VSS.n1937 VSS.n31 4.5005
R2788 VSS.n47 VSS.n31 4.5005
R2789 VSS.n1909 VSS.n31 4.5005
R2790 VSS.n1935 VSS.n31 4.5005
R2791 VSS.n1937 VSS.n14 4.5005
R2792 VSS.n47 VSS.n14 4.5005
R2793 VSS.n1909 VSS.n14 4.5005
R2794 VSS.n1935 VSS.n14 4.5005
R2795 VSS.n1937 VSS.n32 4.5005
R2796 VSS.n47 VSS.n32 4.5005
R2797 VSS.n1909 VSS.n32 4.5005
R2798 VSS.n1935 VSS.n32 4.5005
R2799 VSS.n1937 VSS.n13 4.5005
R2800 VSS.n47 VSS.n13 4.5005
R2801 VSS.n1909 VSS.n13 4.5005
R2802 VSS.n1935 VSS.n13 4.5005
R2803 VSS.n1937 VSS.n33 4.5005
R2804 VSS.n47 VSS.n33 4.5005
R2805 VSS.n1909 VSS.n33 4.5005
R2806 VSS.n1935 VSS.n33 4.5005
R2807 VSS.n1937 VSS.n12 4.5005
R2808 VSS.n47 VSS.n12 4.5005
R2809 VSS.n1909 VSS.n12 4.5005
R2810 VSS.n1935 VSS.n12 4.5005
R2811 VSS.n1937 VSS.n34 4.5005
R2812 VSS.n47 VSS.n34 4.5005
R2813 VSS.n1909 VSS.n34 4.5005
R2814 VSS.n1935 VSS.n34 4.5005
R2815 VSS.n1937 VSS.n11 4.5005
R2816 VSS.n47 VSS.n11 4.5005
R2817 VSS.n1909 VSS.n11 4.5005
R2818 VSS.n1935 VSS.n11 4.5005
R2819 VSS.n1937 VSS.n35 4.5005
R2820 VSS.n47 VSS.n35 4.5005
R2821 VSS.n1909 VSS.n35 4.5005
R2822 VSS.n1935 VSS.n35 4.5005
R2823 VSS.n1937 VSS.n10 4.5005
R2824 VSS.n47 VSS.n10 4.5005
R2825 VSS.n1909 VSS.n10 4.5005
R2826 VSS.n1935 VSS.n10 4.5005
R2827 VSS.n1937 VSS.n36 4.5005
R2828 VSS.n47 VSS.n36 4.5005
R2829 VSS.n1909 VSS.n36 4.5005
R2830 VSS.n1935 VSS.n36 4.5005
R2831 VSS.n1937 VSS.n9 4.5005
R2832 VSS.n47 VSS.n9 4.5005
R2833 VSS.n1909 VSS.n9 4.5005
R2834 VSS.n1935 VSS.n9 4.5005
R2835 VSS.n1937 VSS.n37 4.5005
R2836 VSS.n47 VSS.n37 4.5005
R2837 VSS.n1909 VSS.n37 4.5005
R2838 VSS.n1935 VSS.n37 4.5005
R2839 VSS.n1937 VSS.n8 4.5005
R2840 VSS.n47 VSS.n8 4.5005
R2841 VSS.n1909 VSS.n8 4.5005
R2842 VSS.n1935 VSS.n8 4.5005
R2843 VSS.n1937 VSS.n38 4.5005
R2844 VSS.n47 VSS.n38 4.5005
R2845 VSS.n1909 VSS.n38 4.5005
R2846 VSS.n1935 VSS.n38 4.5005
R2847 VSS.n1937 VSS.n7 4.5005
R2848 VSS.n47 VSS.n7 4.5005
R2849 VSS.n1909 VSS.n7 4.5005
R2850 VSS.n1935 VSS.n7 4.5005
R2851 VSS.n1937 VSS.n39 4.5005
R2852 VSS.n47 VSS.n39 4.5005
R2853 VSS.n1909 VSS.n39 4.5005
R2854 VSS.n1935 VSS.n39 4.5005
R2855 VSS.n1937 VSS.n6 4.5005
R2856 VSS.n47 VSS.n6 4.5005
R2857 VSS.n1909 VSS.n6 4.5005
R2858 VSS.n1935 VSS.n6 4.5005
R2859 VSS.n1937 VSS.n40 4.5005
R2860 VSS.n47 VSS.n40 4.5005
R2861 VSS.n1909 VSS.n40 4.5005
R2862 VSS.n1935 VSS.n40 4.5005
R2863 VSS.n1937 VSS.n5 4.5005
R2864 VSS.n47 VSS.n5 4.5005
R2865 VSS.n1909 VSS.n5 4.5005
R2866 VSS.n1935 VSS.n5 4.5005
R2867 VSS.n1937 VSS.n41 4.5005
R2868 VSS.n47 VSS.n41 4.5005
R2869 VSS.n1909 VSS.n41 4.5005
R2870 VSS.n1935 VSS.n41 4.5005
R2871 VSS.n1937 VSS.n4 4.5005
R2872 VSS.n47 VSS.n4 4.5005
R2873 VSS.n1909 VSS.n4 4.5005
R2874 VSS.n1935 VSS.n4 4.5005
R2875 VSS.n1937 VSS.n42 4.5005
R2876 VSS.n47 VSS.n42 4.5005
R2877 VSS.n1909 VSS.n42 4.5005
R2878 VSS.n1935 VSS.n42 4.5005
R2879 VSS.n1937 VSS.n3 4.5005
R2880 VSS.n47 VSS.n3 4.5005
R2881 VSS.n1909 VSS.n3 4.5005
R2882 VSS.n1935 VSS.n3 4.5005
R2883 VSS.n1937 VSS.n43 4.5005
R2884 VSS.n47 VSS.n43 4.5005
R2885 VSS.n1909 VSS.n43 4.5005
R2886 VSS.n1935 VSS.n43 4.5005
R2887 VSS.n1937 VSS.n2 4.5005
R2888 VSS.n47 VSS.n2 4.5005
R2889 VSS.n1909 VSS.n2 4.5005
R2890 VSS.n1935 VSS.n2 4.5005
R2891 VSS.n1937 VSS.n44 4.5005
R2892 VSS.n47 VSS.n44 4.5005
R2893 VSS.n1909 VSS.n44 4.5005
R2894 VSS.n1935 VSS.n44 4.5005
R2895 VSS.n1937 VSS.n1 4.5005
R2896 VSS.n47 VSS.n1 4.5005
R2897 VSS.n1909 VSS.n1 4.5005
R2898 VSS.n1935 VSS.n1 4.5005
R2899 VSS.n1937 VSS.n1936 4.5005
R2900 VSS.n1936 VSS.n47 4.5005
R2901 VSS.n1936 VSS.n1935 4.5005
R2902 VSS.t169 VSS.n776 4.4841
R2903 VSS.t137 VSS.n1828 4.29549
R2904 VSS.n1935 VSS.n1885 4.10793
R2905 VSS.n1792 VSS.n1791 3.98316
R2906 VSS.n419 VSS.n418 3.98316
R2907 VSS.n180 VSS.n107 3.98316
R2908 VSS.n606 VSS.n605 3.98271
R2909 VSS.n1451 VSS.n1450 3.98271
R2910 VSS.n1046 VSS.n1045 3.98271
R2911 VSS.n674 VSS.n673 3.98271
R2912 VSS.n1745 VSS.n114 3.9819
R2913 VSS.n474 VSS.n426 3.9819
R2914 VSS.n1564 VSS.n1563 3.9819
R2915 VSS.n1310 VSS.n1295 3.9819
R2916 VSS.n922 VSS.n889 3.9819
R2917 VSS.n1466 VSS.n1464 3.9819
R2918 VSS.n1802 VSS.n1801 3.9819
R2919 VSS.n1153 VSS.t1 3.77274
R2920 VSS.n1161 VSS.n1160 3.51761
R2921 VSS.n1163 VSS.n1162 3.51761
R2922 VSS.n1165 VSS.n1164 3.51761
R2923 VSS.n1167 VSS.n1166 3.51761
R2924 VSS.n1182 VSS.n1179 3.51761
R2925 VSS.n1181 VSS.n1180 3.51761
R2926 VSS.n783 VSS.n782 3.51761
R2927 VSS.n785 VSS.n784 3.51761
R2928 VSS.n1054 VSS.t303 3.49603
R2929 VSS.n1173 VSS.n1158 3.47261
R2930 VSS.n1174 VSS.n1157 3.47261
R2931 VSS.n1176 VSS.n1156 3.47261
R2932 VSS.n1177 VSS.n1155 3.47261
R2933 VSS.t192 VSS.n1098 3.45183
R2934 VSS.t259 VSS.n1082 3.45183
R2935 VSS.n1245 VSS.n1244 3.45183
R2936 VSS.n1237 VSS.t132 3.15666
R2937 VSS.n94 VSS.t156 3.15666
R2938 VSS.n1140 VSS.t76 3.15666
R2939 VSS.n1135 VSS.t73 3.15666
R2940 VSS.n1885 VSS.n1884 3.09159
R2941 VSS.n1883 VSS.n1882 2.92955
R2942 VSS.t304 VSS.t6 2.83826
R2943 VSS.t254 VSS.t9 2.83826
R2944 VSS.t292 VSS.t150 2.83826
R2945 VSS.n1883 VSS.n50 2.80715
R2946 VSS.n681 VSS.t239 2.78958
R2947 VSS.n325 VSS.n22 2.74618
R2948 VSS.n1191 VSS.n780 2.73366
R2949 VSS.n1192 VSS 2.73247
R2950 VSS.n1288 VSS.n1287 2.72525
R2951 VSS.n1204 VSS.t3 2.71983
R2952 VSS.n1809 VSS.t287 2.71983
R2953 VSS.n1228 VSS.t258 2.71983
R2954 VSS.n1867 VSS.n70 2.60817
R2955 VSS.n803 VSS.t41 2.5835
R2956 VSS.n800 VSS.t35 2.5835
R2957 VSS.n801 VSS.t25 2.5835
R2958 VSS.n798 VSS.t23 2.5835
R2959 VSS.n834 VSS.t20 2.5835
R2960 VSS.n836 VSS.t33 2.5835
R2961 VSS.n837 VSS.t37 2.5835
R2962 VSS.n839 VSS.t39 2.5835
R2963 VSS.n709 VSS.t28 2.5835
R2964 VSS.n711 VSS.t91 2.5835
R2965 VSS.n712 VSS.t98 2.5835
R2966 VSS.n714 VSS.t101 2.5835
R2967 VSS.n1840 VSS.t129 2.5835
R2968 VSS.n1843 VSS.t126 2.5835
R2969 VSS.n1842 VSS.t153 2.5835
R2970 VSS.n1845 VSS.t138 2.5835
R2971 VSS.n1860 VSS.t146 2.5835
R2972 VSS.n1858 VSS.t148 2.5835
R2973 VSS.n1857 VSS.t151 2.5835
R2974 VSS.n1855 VSS.t162 2.5835
R2975 VSS.n705 VSS.t103 2.5835
R2976 VSS.n702 VSS.t96 2.5835
R2977 VSS.n703 VSS.t94 2.5835
R2978 VSS.n700 VSS.t82 2.5835
R2979 VSS.t305 VSS.t180 2.55888
R2980 VSS.t282 VSS.n357 2.55372
R2981 VSS.t301 VSS.n409 2.55372
R2982 VSS.t281 VSS.n410 2.55372
R2983 VSS.n1131 VSS.n769 2.52168
R2984 VSS.n1815 VSS.n101 2.52168
R2985 VSS.n1292 VSS.t210 2.51659
R2986 VSS.n1203 VSS.n769 2.35708
R2987 VSS.n1815 VSS.n1814 2.35708
R2988 VSS.n1652 VSS.n1651 2.34735
R2989 VSS.t305 VSS.n790 2.31261
R2990 VSS.n1260 VSS.n731 2.31261
R2991 VSS.t14 VSS.t285 2.30138
R2992 VSS.t280 VSS.t84 2.30138
R2993 VSS.n1831 VSS.n85 2.30138
R2994 VSS.t305 VSS.n788 2.27462
R2995 VSS.t305 VSS.n680 2.27462
R2996 VSS.n1936 VSS.n48 2.25054
R2997 VSS.n1908 VSS.n22 2.25053
R2998 VSS.n1934 VSS.n22 2.25053
R2999 VSS.n1910 VSS.n0 2.25053
R3000 VSS.n47 VSS.n46 2.24747
R3001 VSS.n1933 VSS.n1932 2.24747
R3002 VSS.n1907 VSS.n1886 2.24747
R3003 VSS.n1933 VSS.n1931 2.24747
R3004 VSS.n1907 VSS.n1887 2.24747
R3005 VSS.n1933 VSS.n1930 2.24747
R3006 VSS.n1907 VSS.n1888 2.24747
R3007 VSS.n1933 VSS.n1929 2.24747
R3008 VSS.n1907 VSS.n1889 2.24747
R3009 VSS.n1933 VSS.n1928 2.24747
R3010 VSS.n1907 VSS.n1890 2.24747
R3011 VSS.n1933 VSS.n1927 2.24747
R3012 VSS.n1907 VSS.n1891 2.24747
R3013 VSS.n1933 VSS.n1926 2.24747
R3014 VSS.n1907 VSS.n1892 2.24747
R3015 VSS.n1933 VSS.n1925 2.24747
R3016 VSS.n1907 VSS.n1893 2.24747
R3017 VSS.n1933 VSS.n1924 2.24747
R3018 VSS.n1907 VSS.n1894 2.24747
R3019 VSS.n1933 VSS.n1923 2.24747
R3020 VSS.n1907 VSS.n1895 2.24747
R3021 VSS.n1933 VSS.n1922 2.24747
R3022 VSS.n1907 VSS.n1896 2.24747
R3023 VSS.n1933 VSS.n1921 2.24747
R3024 VSS.n1907 VSS.n1897 2.24747
R3025 VSS.n1933 VSS.n1920 2.24747
R3026 VSS.n1907 VSS.n1898 2.24747
R3027 VSS.n1933 VSS.n1919 2.24747
R3028 VSS.n1907 VSS.n1899 2.24747
R3029 VSS.n1933 VSS.n1918 2.24747
R3030 VSS.n1907 VSS.n1900 2.24747
R3031 VSS.n1933 VSS.n1917 2.24747
R3032 VSS.n1933 VSS.n1916 2.24747
R3033 VSS.n1907 VSS.n1902 2.24747
R3034 VSS.n1933 VSS.n1915 2.24747
R3035 VSS.n1907 VSS.n1903 2.24747
R3036 VSS.n1933 VSS.n1914 2.24747
R3037 VSS.n1907 VSS.n1904 2.24747
R3038 VSS.n1933 VSS.n1913 2.24747
R3039 VSS.n1907 VSS.n1905 2.24747
R3040 VSS.n1933 VSS.n1912 2.24747
R3041 VSS.n1907 VSS.n1906 2.24747
R3042 VSS.n1933 VSS.n1911 2.24747
R3043 VSS.n1907 VSS.n45 2.24747
R3044 VSS.n1907 VSS.n1901 2.24696
R3045 VSS.n1265 VSS.n731 2.22469
R3046 VSS.n1867 VSS.n73 2.22469
R3047 VSS.n73 VSS.n54 2.19516
R3048 VSS.n1820 VSS.n1819 2.19366
R3049 VSS.n1819 VSS.n97 2.19366
R3050 VSS.n1652 VSS.n325 2.1891
R3051 VSS.n1784 VSS.n115 2.18398
R3052 VSS.n1784 VSS.n1783 2.18398
R3053 VSS.n1783 VSS.n123 2.18398
R3054 VSS.n126 VSS.n123 2.18398
R3055 VSS.n1743 VSS.n126 2.18398
R3056 VSS.n1746 VSS.n1743 2.18398
R3057 VSS.n479 VSS.n453 2.18398
R3058 VSS.n551 VSS.n550 2.18398
R3059 VSS.n556 VSS.n439 2.18398
R3060 VSS.n412 VSS.n351 2.18398
R3061 VSS.n1602 VSS.n351 2.18398
R3062 VSS.n1602 VSS.n1601 2.18398
R3063 VSS.n1601 VSS.n1600 2.18398
R3064 VSS.n1600 VSS.n354 2.18398
R3065 VSS.n1565 VSS.n354 2.18398
R3066 VSS.n1339 VSS.n1316 2.18398
R3067 VSS.n1336 VSS.n1327 2.18398
R3068 VSS.n1347 VSS.n1346 2.18398
R3069 VSS.n1005 VSS.n1004 2.18398
R3070 VSS.n1008 VSS.n1007 2.18398
R3071 VSS.n949 VSS.n947 2.18398
R3072 VSS.n1471 VSS.n1468 2.18398
R3073 VSS.n1469 VSS.n631 2.18398
R3074 VSS.n1479 VSS.n643 2.18398
R3075 VSS.n187 VSS.n186 2.18398
R3076 VSS.n275 VSS.n187 2.18398
R3077 VSS.n275 VSS.n274 2.18398
R3078 VSS.n274 VSS.n273 2.18398
R3079 VSS.n273 VSS.n190 2.18398
R3080 VSS.n190 VSS.n108 2.18398
R3081 VSS.n1199 VSS.n1198 2.14866
R3082 VSS.n1198 VSS.n771 2.14866
R3083 VSS.n855 VSS.t61 2.14866
R3084 VSS.n810 VSS.t64 2.14866
R3085 VSS.n63 VSS.t111 2.14866
R3086 VSS.n1249 VSS.t109 2.14866
R3087 VSS.n740 VSS.t144 2.14866
R3088 VSS.n736 VSS.t135 2.14866
R3089 VSS.n215 VSS.n189 2.13898
R3090 VSS.n274 VSS.n189 2.13898
R3091 VSS.n1785 VSS.n122 2.13898
R3092 VSS.n1785 VSS.n1784 2.13898
R3093 VSS.n1714 VSS.n1713 2.13898
R3094 VSS.n1713 VSS.n123 2.13898
R3095 VSS.n1742 VSS.n1733 2.13898
R3096 VSS.n1743 VSS.n1742 2.13898
R3097 VSS.n1791 VSS.n115 2.13898
R3098 VSS.n1746 VSS.n1745 2.13898
R3099 VSS.n475 VSS.n474 2.13898
R3100 VSS.n475 VSS.n453 2.13898
R3101 VSS.n480 VSS.n479 2.13898
R3102 VSS.n453 VSS.n441 2.13898
R3103 VSS.n551 VSS.n441 2.13898
R3104 VSS.n550 VSS.n442 2.13898
R3105 VSS.n552 VSS.n551 2.13898
R3106 VSS.n552 VSS.n439 2.13898
R3107 VSS.n557 VSS.n556 2.13898
R3108 VSS.n439 VSS.n427 2.13898
R3109 VSS.n605 VSS.n427 2.13898
R3110 VSS.n1619 VSS.n338 2.13898
R3111 VSS.n351 VSS.n338 2.13898
R3112 VSS.n380 VSS.n353 2.13898
R3113 VSS.n1601 VSS.n353 2.13898
R3114 VSS.n407 VSS.n399 2.13898
R3115 VSS.n407 VSS.n354 2.13898
R3116 VSS.n418 VSS.n412 2.13898
R3117 VSS.n1565 VSS.n1564 2.13898
R3118 VSS.n1338 VSS.n1310 2.13898
R3119 VSS.n1339 VSS.n1338 2.13898
R3120 VSS.n1430 VSS.n1316 2.13898
R3121 VSS.n1340 VSS.n1339 2.13898
R3122 VSS.n1340 VSS.n1336 2.13898
R3123 VSS.n1345 VSS.n1336 2.13898
R3124 VSS.n1346 VSS.n1345 2.13898
R3125 VSS.n1401 VSS.n1327 2.13898
R3126 VSS.n1348 VSS.n1347 2.13898
R3127 VSS.n1346 VSS.n1296 2.13898
R3128 VSS.n1450 VSS.n1296 2.13898
R3129 VSS.n947 VSS.n909 2.13898
R3130 VSS.n1005 VSS.n909 2.13898
R3131 VSS.n1004 VSS.n910 2.13898
R3132 VSS.n1006 VSS.n1005 2.13898
R3133 VSS.n1007 VSS.n1006 2.13898
R3134 VSS.n1008 VSS.n898 2.13898
R3135 VSS.n1007 VSS.n890 2.13898
R3136 VSS.n1045 VSS.n890 2.13898
R3137 VSS.n950 VSS.n949 2.13898
R3138 VSS.n946 VSS.n922 2.13898
R3139 VSS.n947 VSS.n946 2.13898
R3140 VSS.n1472 VSS.n1466 2.13898
R3141 VSS.n1472 VSS.n1471 2.13898
R3142 VSS.n1468 VSS.n621 2.13898
R3143 VSS.n1471 VSS.n1470 2.13898
R3144 VSS.n1470 VSS.n1469 2.13898
R3145 VSS.n1469 VSS.n648 2.13898
R3146 VSS.n648 VSS.n643 2.13898
R3147 VSS.n1509 VSS.n631 2.13898
R3148 VSS.n1480 VSS.n1479 2.13898
R3149 VSS.n652 VSS.n643 2.13898
R3150 VSS.n673 VSS.n652 2.13898
R3151 VSS.n292 VSS.n167 2.13898
R3152 VSS.n187 VSS.n167 2.13898
R3153 VSS.n236 VSS.n235 2.13898
R3154 VSS.n235 VSS.n190 2.13898
R3155 VSS.n186 VSS.n180 2.13898
R3156 VSS.n1801 VSS.n108 2.13898
R3157 VSS.n1292 VSS.t233 2.11932
R3158 VSS.n1205 VSS.n1204 2.0805
R3159 VSS.n1053 VSS.n768 2.0805
R3160 VSS.n1809 VSS.n1808 2.0805
R3161 VSS.n1117 VSS.t290 2.0805
R3162 VSS.t305 VSS.n685 2.0805
R3163 VSS.t305 VSS.n789 2.0805
R3164 VSS.t305 VSS.n792 2.0805
R3165 VSS.n73 VSS.n72 2.0805
R3166 VSS.n1228 VSS.t257 2.0805
R3167 VSS.n1227 VSS.t256 2.0805
R3168 VSS.n1261 VSS.n731 2.0805
R3169 VSS.n1226 VSS.t0 2.0805
R3170 VSS.t255 VSS.n757 2.0805
R3171 VSS.n1084 VSS.t259 2.0805
R3172 VSS.n1074 VSS.t280 2.0805
R3173 VSS.n1070 VSS.t285 2.0805
R3174 VSS.t192 VSS.n1058 2.0805
R3175 VSS.t307 VSS.n880 2.0805
R3176 VSS.n881 VSS.t289 2.0805
R3177 VSS.t210 VSS.n683 2.0805
R3178 VSS.n756 VSS.n755 2.06103
R3179 VSS.n93 VSS.n92 2.06103
R3180 VSS.n1127 VSS.n1124 2.06103
R3181 VSS.n1116 VSS.n1115 2.06103
R3182 VSS.n1289 VSS.n1288 1.98781
R3183 VSS.n90 VSS.t160 1.98608
R3184 VSS.n753 VSS.t158 1.98608
R3185 VSS.n1149 VSS.t80 1.98608
R3186 VSS.n1113 VSS.t78 1.98608
R3187 VSS.n1178 VSS.t70 1.94108
R3188 VSS.n1172 VSS.t67 1.94108
R3189 VSS.n1233 VSS.n70 1.9179
R3190 VSS.n1289 VSS.n685 1.86386
R3191 VSS.n832 VSS.n825 1.81708
R3192 VSS.n876 VSS.n875 1.81708
R3193 VSS.n1849 VSS.n1848 1.81708
R3194 VSS.n1853 VSS.n79 1.81708
R3195 VSS.n1280 VSS.n1279 1.81708
R3196 VSS.n718 VSS.n717 1.81708
R3197 VSS.n753 VSS.n752 1.80879
R3198 VSS.n1150 VSS.n1149 1.80879
R3199 VSS.n1290 VSS.n1289 1.80672
R3200 VSS.n752 VSS.n90 1.74958
R3201 VSS.n1150 VSS.n1113 1.74958
R3202 VSS.n1224 VSS.n1223 1.72007
R3203 VSS.t169 VSS.n1194 1.60777
R3204 VSS.n1199 VSS.n770 1.53642
R3205 VSS.n1874 VSS.t203 1.53442
R3206 VSS.n843 VSS.t18 1.53217
R3207 VSS.n872 VSS.t52 1.53217
R3208 VSS.n1268 VSS.t113 1.53217
R3209 VSS.n1864 VSS.t121 1.53217
R3210 VSS.n1835 VSS.t142 1.53217
R3211 VSS.n721 VSS.t119 1.53217
R3212 VSS.n814 VSS.n813 1.51866
R3213 VSS.n866 VSS.n811 1.51866
R3214 VSS.n1871 VSS.n64 1.51866
R3215 VSS.n67 VSS.n66 1.51866
R3216 VSS.n742 VSS.n738 1.51866
R3217 VSS.n745 VSS.n737 1.51866
R3218 VSS.n841 VSS.n825 1.49734
R3219 VSS.n875 VSS.n874 1.49734
R3220 VSS.n1848 VSS.n1847 1.49734
R3221 VSS.n1862 VSS.n79 1.49734
R3222 VSS.n1279 VSS.n1278 1.49734
R3223 VSS.n718 VSS.n716 1.49734
R3224 VSS.n1216 VSS.n1215 1.48208
R3225 VSS.n1212 VSS.n765 1.48208
R3226 VSS.n1812 VSS.n50 1.44642
R3227 VSS.n1221 VSS.n761 1.4405
R3228 VSS.n1222 VSS.n1221 1.4405
R3229 VSS.n1071 VSS.n1069 1.43708
R3230 VSS.n1133 VSS.n1132 1.418
R3231 VSS.n1236 VSS.n1235 1.38569
R3232 VSS.n1235 VSS.n1229 1.38569
R3233 VSS.n1142 VSS.n1141 1.38569
R3234 VSS.t191 VSS.t11 1.38103
R3235 VSS.n1200 VSS.n1199 1.37418
R3236 VSS.n1129 VSS.n771 1.37418
R3237 VSS.n1821 VSS.n95 1.373
R3238 VSS.n1240 VSS.n756 1.34576
R3239 VSS.n1824 VSS.n93 1.34576
R3240 VSS.n1128 VSS.n1127 1.34576
R3241 VSS.n1146 VSS.n1116 1.34576
R3242 VSS.n1055 VSS.n1054 1.3378
R3243 VSS.n1186 VSS.n1185 1.33747
R3244 VSS.n1820 VSS.n96 1.32918
R3245 VSS.n1810 VSS.n97 1.32918
R3246 VSS.t201 VSS.n1073 1.30433
R3247 VSS.n1284 VSS.t27 1.30433
R3248 VSS.n1201 VSS.n1200 1.29839
R3249 VSS.n1811 VSS.n1810 1.29839
R3250 VSS.n1130 VSS.n1129 1.29721
R3251 VSS.n100 VSS.n96 1.29721
R3252 VSS.n1290 VSS.n684 1.27083
R3253 VSS.n583 VSS.n582 1.26666
R3254 VSS.n1087 VSS.n1058 1.2605
R3255 VSS.n1085 VSS.n1084 1.2605
R3256 VSS.n1202 VSS.n770 1.25458
R3257 VSS.n1813 VSS.n1812 1.25458
R3258 VSS.n1132 VSS.n1131 1.25339
R3259 VSS.n101 VSS.n95 1.25339
R3260 VSS.n821 VSS.t47 1.2045
R3261 VSS.n821 VSS.t50 1.2045
R3262 VSS.n727 VSS.t115 1.2045
R3263 VSS.n727 VSS.t117 1.2045
R3264 VSS.n1066 VSS.t15 1.2045
R3265 VSS.n1075 VSS.t85 1.2045
R3266 VSS.n68 VSS.t123 1.2045
R3267 VSS.n68 VSS.t140 1.2045
R3268 VSS.n1213 VSS.t88 1.2045
R3269 VSS.n767 VSS.t106 1.2045
R3270 VSS.n1826 VSS.n90 1.18945
R3271 VSS.n1242 VSS.n753 1.18945
R3272 VSS.n1149 VSS.n1148 1.18945
R3273 VSS.n1122 VSS.n1113 1.18945
R3274 VSS.n1099 VSS.t260 1.18468
R3275 VSS.n1838 VSS.n1837 1.16458
R3276 VSS.n1158 VSS.t226 1.0925
R3277 VSS.n1158 VSS.t227 1.0925
R3278 VSS.n1157 VSS.t229 1.0925
R3279 VSS.n1157 VSS.t236 1.0925
R3280 VSS.n1156 VSS.t238 1.0925
R3281 VSS.n1156 VSS.t231 1.0925
R3282 VSS.n1155 VSS.t232 1.0925
R3283 VSS.n1155 VSS.t240 1.0925
R3284 VSS.n1160 VSS.t55 1.0925
R3285 VSS.n1160 VSS.t212 1.0925
R3286 VSS.n1162 VSS.t214 1.0925
R3287 VSS.n1162 VSS.t216 1.0925
R3288 VSS.n1164 VSS.t218 1.0925
R3289 VSS.n1164 VSS.t220 1.0925
R3290 VSS.n1166 VSS.t222 1.0925
R3291 VSS.n1166 VSS.t224 1.0925
R3292 VSS.n1179 VSS.t242 1.0925
R3293 VSS.n1179 VSS.t244 1.0925
R3294 VSS.n1180 VSS.t234 1.0925
R3295 VSS.n1180 VSS.t246 1.0925
R3296 VSS.n782 VSS.t248 1.0925
R3297 VSS.n782 VSS.t250 1.0925
R3298 VSS.n785 VSS.t252 1.0925
R3299 VSS.t58 VSS.n785 1.0925
R3300 VSS.n1056 VSS.n882 1.0913
R3301 VSS.n1057 VSS.n1056 1.0895
R3302 VSS.n750 VSS.t108 1.07425
R3303 VSS.t134 VSS.n58 1.07425
R3304 VSS.n1851 VSS.t128 1.07425
R3305 VSS.n1171 VSS.n1170 1.07103
R3306 VSS.n1184 VSS.n1183 1.07103
R3307 VSS.n1882 VSS.n51 1.067
R3308 VSS.n828 VSS.n827 1.05866
R3309 VSS.n827 VSS.n826 1.05866
R3310 VSS.n1837 VSS.n80 1.05866
R3311 VSS.n698 VSS.n697 1.05866
R3312 VSS.n874 VSS.n797 1.04261
R3313 VSS.n841 VSS.n797 1.04261
R3314 VSS.n1847 VSS.n78 1.04261
R3315 VSS.n1862 VSS.n78 1.04261
R3316 VSS.n697 VSS.n686 1.04261
R3317 VSS.n1278 VSS.n1277 1.04261
R3318 VSS.n1277 VSS.n716 1.04261
R3319 VSS.n781 VSS.n778 1.0405
R3320 VSS.n1109 VSS.n781 1.0405
R3321 VSS.n1101 VSS.n787 1.0405
R3322 VSS.n1101 VSS.n1100 1.0405
R3323 VSS.n73 VSS.n53 1.0166
R3324 VSS.n1247 VSS.n731 1.0166
R3325 VSS.n1084 VSS.n757 1.00945
R3326 VSS.n1227 VSS.n1226 1.00945
R3327 VSS.n1117 VSS.n683 1.00945
R3328 VSS.n881 VSS.n880 1.00945
R3329 VSS.n1083 VSS.t93 1.0092
R3330 VSS.n1208 VSS.n768 0.978658
R3331 VSS.n1096 VSS.n1095 0.968
R3332 VSS.n1080 VSS.n688 0.968
R3333 VSS.n1142 VSS.n779 0.964559
R3334 VSS.n1186 VSS.n1153 0.951421
R3335 VSS.n1078 VSS.n1076 0.947868
R3336 VSS.n1089 VSS.n1065 0.947868
R3337 VSS.n1214 VSS.n759 0.944316
R3338 VSS.n1211 VSS.n1210 0.944316
R3339 VSS.n837 VSS.n836 0.917079
R3340 VSS.n801 VSS.n800 0.917079
R3341 VSS.n1087 VSS.n1086 0.917079
R3342 VSS.n1086 VSS.n1085 0.917079
R3343 VSS.n1858 VSS.n1857 0.917079
R3344 VSS.n1843 VSS.n1842 0.917079
R3345 VSS.n703 VSS.n702 0.917079
R3346 VSS.n712 VSS.n711 0.917079
R3347 VSS.n847 VSS.n846 0.870895
R3348 VSS.n854 VSS.n853 0.870895
R3349 VSS.n1251 VSS.n1250 0.870895
R3350 VSS.n1255 VSS.n1254 0.870895
R3351 VSS.n739 VSS.n52 0.870895
R3352 VSS.n1877 VSS.n55 0.870895
R3353 VSS.n1286 VSS.n1285 0.867167
R3354 VSS.n1285 VSS.n1284 0.867167
R3355 VSS.n1081 VSS.n1080 0.867167
R3356 VSS.n1082 VSS.n1081 0.867167
R3357 VSS.n1097 VSS.n1096 0.867167
R3358 VSS.n1098 VSS.n1097 0.867167
R3359 VSS.n1094 VSS.n1093 0.867167
R3360 VSS.n1093 VSS.n1092 0.867167
R3361 VSS.n1283 VSS.n1282 0.844158
R3362 VSS.n1228 VSS.n1227 0.79695
R3363 VSS.n1204 VSS.n1203 0.786292
R3364 VSS.n1814 VSS.n1809 0.786292
R3365 VSS.n1884 VSS.n1883 0.78395
R3366 VSS.n1214 VSS.n1213 0.782079
R3367 VSS.n1211 VSS.n767 0.782079
R3368 VSS.n1224 VSS.n758 0.78076
R3369 VSS.n324 VSS.n323 0.76445
R3370 VSS.n1651 VSS.n1650 0.76445
R3371 VSS.n1654 VSS.n1653 0.76445
R3372 VSS.n585 VSS.n583 0.76445
R3373 VSS.n1096 VSS.n1061 0.755002
R3374 VSS.n1080 VSS.n687 0.755002
R3375 VSS.n822 VSS.n805 0.754842
R3376 VSS.n823 VSS.n822 0.754842
R3377 VSS.n1833 VSS.n84 0.754842
R3378 VSS.n84 VSS.n77 0.754842
R3379 VSS.n1272 VSS.n1271 0.754842
R3380 VSS.n1271 VSS.n1270 0.754842
R3381 VSS.n1751 VSS.n1750 0.7505
R3382 VSS.n1752 VSS.n1737 0.7505
R3383 VSS.n1754 VSS.n1753 0.7505
R3384 VSS.n1755 VSS.n1736 0.7505
R3385 VSS.n1757 VSS.n1756 0.7505
R3386 VSS.n1758 VSS.n1735 0.7505
R3387 VSS.n1760 VSS.n1759 0.7505
R3388 VSS.n1761 VSS.n1734 0.7505
R3389 VSS.n1763 VSS.n1762 0.7505
R3390 VSS.n1765 VSS.n1764 0.7505
R3391 VSS.n1766 VSS.n1732 0.7505
R3392 VSS.n1768 VSS.n1767 0.7505
R3393 VSS.n1769 VSS.n1731 0.7505
R3394 VSS.n1771 VSS.n1770 0.7505
R3395 VSS.n1772 VSS.n1730 0.7505
R3396 VSS.n1774 VSS.n1773 0.7505
R3397 VSS.n1775 VSS.n132 0.7505
R3398 VSS.n1777 VSS.n1776 0.7505
R3399 VSS.n1729 VSS.n131 0.7505
R3400 VSS.n1728 VSS.n1727 0.7505
R3401 VSS.n1726 VSS.n133 0.7505
R3402 VSS.n1725 VSS.n1724 0.7505
R3403 VSS.n1723 VSS.n134 0.7505
R3404 VSS.n1722 VSS.n1721 0.7505
R3405 VSS.n1720 VSS.n135 0.7505
R3406 VSS.n1719 VSS.n1718 0.7505
R3407 VSS.n1717 VSS.n136 0.7505
R3408 VSS.n1716 VSS.n1715 0.7505
R3409 VSS.n1712 VSS.n137 0.7505
R3410 VSS.n1711 VSS.n1710 0.7505
R3411 VSS.n1709 VSS.n138 0.7505
R3412 VSS.n1708 VSS.n1707 0.7505
R3413 VSS.n1706 VSS.n139 0.7505
R3414 VSS.n1705 VSS.n1704 0.7505
R3415 VSS.n1703 VSS.n140 0.7505
R3416 VSS.n1702 VSS.n1701 0.7505
R3417 VSS.n1698 VSS.n141 0.7505
R3418 VSS.n1697 VSS.n1696 0.7505
R3419 VSS.n1695 VSS.n142 0.7505
R3420 VSS.n1694 VSS.n1693 0.7505
R3421 VSS.n1692 VSS.n143 0.7505
R3422 VSS.n1691 VSS.n1690 0.7505
R3423 VSS.n1689 VSS.n144 0.7505
R3424 VSS.n1688 VSS.n1687 0.7505
R3425 VSS.n1686 VSS.n1685 0.7505
R3426 VSS.n1684 VSS.n1683 0.7505
R3427 VSS.n1682 VSS.n145 0.7505
R3428 VSS.n1681 VSS.n1680 0.7505
R3429 VSS.n1679 VSS.n146 0.7505
R3430 VSS.n1678 VSS.n1677 0.7505
R3431 VSS.n1676 VSS.n147 0.7505
R3432 VSS.n1675 VSS.n1674 0.7505
R3433 VSS.n1673 VSS.n148 0.7505
R3434 VSS.n1672 VSS.n1671 0.7505
R3435 VSS.n1669 VSS.n149 0.7505
R3436 VSS.n1668 VSS.n1667 0.7505
R3437 VSS.n1666 VSS.n150 0.7505
R3438 VSS.n1665 VSS.n1664 0.7505
R3439 VSS.n1663 VSS.n151 0.7505
R3440 VSS.n1662 VSS.n1661 0.7505
R3441 VSS.n1660 VSS.n152 0.7505
R3442 VSS.n1659 VSS.n1658 0.7505
R3443 VSS.n1657 VSS.n153 0.7505
R3444 VSS.n1656 VSS.n1655 0.7505
R3445 VSS.n1654 VSS.n154 0.7505
R3446 VSS.n585 VSS.n584 0.7505
R3447 VSS.n586 VSS.n576 0.7505
R3448 VSS.n588 VSS.n587 0.7505
R3449 VSS.n589 VSS.n575 0.7505
R3450 VSS.n591 VSS.n590 0.7505
R3451 VSS.n592 VSS.n574 0.7505
R3452 VSS.n594 VSS.n593 0.7505
R3453 VSS.n595 VSS.n573 0.7505
R3454 VSS.n597 VSS.n596 0.7505
R3455 VSS.n598 VSS.n432 0.7505
R3456 VSS.n600 VSS.n599 0.7505
R3457 VSS.n572 VSS.n431 0.7505
R3458 VSS.n571 VSS.n570 0.7505
R3459 VSS.n569 VSS.n433 0.7505
R3460 VSS.n568 VSS.n567 0.7505
R3461 VSS.n566 VSS.n434 0.7505
R3462 VSS.n565 VSS.n564 0.7505
R3463 VSS.n563 VSS.n435 0.7505
R3464 VSS.n562 VSS.n561 0.7505
R3465 VSS.n560 VSS.n436 0.7505
R3466 VSS.n559 VSS.n558 0.7505
R3467 VSS.n438 VSS.n437 0.7505
R3468 VSS.n507 VSS.n506 0.7505
R3469 VSS.n509 VSS.n508 0.7505
R3470 VSS.n510 VSS.n505 0.7505
R3471 VSS.n512 VSS.n511 0.7505
R3472 VSS.n513 VSS.n504 0.7505
R3473 VSS.n515 VSS.n514 0.7505
R3474 VSS.n516 VSS.n503 0.7505
R3475 VSS.n519 VSS.n518 0.7505
R3476 VSS.n520 VSS.n502 0.7505
R3477 VSS.n522 VSS.n521 0.7505
R3478 VSS.n523 VSS.n501 0.7505
R3479 VSS.n525 VSS.n524 0.7505
R3480 VSS.n526 VSS.n500 0.7505
R3481 VSS.n528 VSS.n527 0.7505
R3482 VSS.n529 VSS.n499 0.7505
R3483 VSS.n531 VSS.n530 0.7505
R3484 VSS.n533 VSS.n532 0.7505
R3485 VSS.n534 VSS.n498 0.7505
R3486 VSS.n536 VSS.n535 0.7505
R3487 VSS.n537 VSS.n497 0.7505
R3488 VSS.n539 VSS.n538 0.7505
R3489 VSS.n540 VSS.n496 0.7505
R3490 VSS.n542 VSS.n541 0.7505
R3491 VSS.n543 VSS.n446 0.7505
R3492 VSS.n545 VSS.n544 0.7505
R3493 VSS.n495 VSS.n445 0.7505
R3494 VSS.n494 VSS.n493 0.7505
R3495 VSS.n492 VSS.n447 0.7505
R3496 VSS.n491 VSS.n490 0.7505
R3497 VSS.n489 VSS.n448 0.7505
R3498 VSS.n488 VSS.n487 0.7505
R3499 VSS.n486 VSS.n449 0.7505
R3500 VSS.n485 VSS.n484 0.7505
R3501 VSS.n483 VSS.n450 0.7505
R3502 VSS.n482 VSS.n481 0.7505
R3503 VSS.n452 VSS.n451 0.7505
R3504 VSS.n460 VSS.n459 0.7505
R3505 VSS.n462 VSS.n461 0.7505
R3506 VSS.n463 VSS.n458 0.7505
R3507 VSS.n465 VSS.n464 0.7505
R3508 VSS.n466 VSS.n457 0.7505
R3509 VSS.n468 VSS.n467 0.7505
R3510 VSS.n469 VSS.n456 0.7505
R3511 VSS.n580 VSS.n577 0.7505
R3512 VSS.n579 VSS.n578 0.7505
R3513 VSS.n405 VSS.n404 0.7505
R3514 VSS.n1570 VSS.n1569 0.7505
R3515 VSS.n1571 VSS.n403 0.7505
R3516 VSS.n1573 VSS.n1572 0.7505
R3517 VSS.n1574 VSS.n402 0.7505
R3518 VSS.n1576 VSS.n1575 0.7505
R3519 VSS.n1577 VSS.n401 0.7505
R3520 VSS.n1579 VSS.n1578 0.7505
R3521 VSS.n1580 VSS.n400 0.7505
R3522 VSS.n1582 VSS.n1581 0.7505
R3523 VSS.n1584 VSS.n1583 0.7505
R3524 VSS.n1585 VSS.n398 0.7505
R3525 VSS.n1587 VSS.n1586 0.7505
R3526 VSS.n1588 VSS.n397 0.7505
R3527 VSS.n1590 VSS.n1589 0.7505
R3528 VSS.n1591 VSS.n396 0.7505
R3529 VSS.n1593 VSS.n1592 0.7505
R3530 VSS.n1594 VSS.n360 0.7505
R3531 VSS.n1596 VSS.n1595 0.7505
R3532 VSS.n395 VSS.n359 0.7505
R3533 VSS.n394 VSS.n393 0.7505
R3534 VSS.n392 VSS.n361 0.7505
R3535 VSS.n391 VSS.n390 0.7505
R3536 VSS.n389 VSS.n362 0.7505
R3537 VSS.n388 VSS.n387 0.7505
R3538 VSS.n386 VSS.n363 0.7505
R3539 VSS.n385 VSS.n384 0.7505
R3540 VSS.n383 VSS.n364 0.7505
R3541 VSS.n382 VSS.n381 0.7505
R3542 VSS.n379 VSS.n365 0.7505
R3543 VSS.n378 VSS.n377 0.7505
R3544 VSS.n376 VSS.n366 0.7505
R3545 VSS.n375 VSS.n374 0.7505
R3546 VSS.n373 VSS.n367 0.7505
R3547 VSS.n372 VSS.n371 0.7505
R3548 VSS.n370 VSS.n368 0.7505
R3549 VSS.n369 VSS.n343 0.7505
R3550 VSS.n1606 VSS.n342 0.7505
R3551 VSS.n1608 VSS.n1607 0.7505
R3552 VSS.n1609 VSS.n341 0.7505
R3553 VSS.n1611 VSS.n1610 0.7505
R3554 VSS.n1612 VSS.n340 0.7505
R3555 VSS.n1614 VSS.n1613 0.7505
R3556 VSS.n1615 VSS.n339 0.7505
R3557 VSS.n1617 VSS.n1616 0.7505
R3558 VSS.n1618 VSS.n337 0.7505
R3559 VSS.n1621 VSS.n1620 0.7505
R3560 VSS.n1622 VSS.n336 0.7505
R3561 VSS.n1624 VSS.n1623 0.7505
R3562 VSS.n1625 VSS.n335 0.7505
R3563 VSS.n1627 VSS.n1626 0.7505
R3564 VSS.n1628 VSS.n334 0.7505
R3565 VSS.n1630 VSS.n1629 0.7505
R3566 VSS.n1631 VSS.n333 0.7505
R3567 VSS.n1633 VSS.n1632 0.7505
R3568 VSS.n1635 VSS.n1634 0.7505
R3569 VSS.n1636 VSS.n331 0.7505
R3570 VSS.n1638 VSS.n1637 0.7505
R3571 VSS.n1639 VSS.n330 0.7505
R3572 VSS.n1641 VSS.n1640 0.7505
R3573 VSS.n1642 VSS.n329 0.7505
R3574 VSS.n1644 VSS.n1643 0.7505
R3575 VSS.n1645 VSS.n328 0.7505
R3576 VSS.n1647 VSS.n1646 0.7505
R3577 VSS.n1648 VSS.n327 0.7505
R3578 VSS.n1650 VSS.n1649 0.7505
R3579 VSS.n1355 VSS.n1354 0.7505
R3580 VSS.n1356 VSS.n1352 0.7505
R3581 VSS.n1358 VSS.n1357 0.7505
R3582 VSS.n1359 VSS.n1351 0.7505
R3583 VSS.n1361 VSS.n1360 0.7505
R3584 VSS.n1362 VSS.n1350 0.7505
R3585 VSS.n1364 VSS.n1363 0.7505
R3586 VSS.n1365 VSS.n1349 0.7505
R3587 VSS.n1367 VSS.n1366 0.7505
R3588 VSS.n1369 VSS.n1368 0.7505
R3589 VSS.n1370 VSS.n1335 0.7505
R3590 VSS.n1372 VSS.n1371 0.7505
R3591 VSS.n1373 VSS.n1334 0.7505
R3592 VSS.n1375 VSS.n1374 0.7505
R3593 VSS.n1376 VSS.n1333 0.7505
R3594 VSS.n1378 VSS.n1377 0.7505
R3595 VSS.n1379 VSS.n1332 0.7505
R3596 VSS.n1381 VSS.n1380 0.7505
R3597 VSS.n1388 VSS.n1331 0.7505
R3598 VSS.n1390 VSS.n1389 0.7505
R3599 VSS.n1391 VSS.n1330 0.7505
R3600 VSS.n1393 VSS.n1392 0.7505
R3601 VSS.n1394 VSS.n1329 0.7505
R3602 VSS.n1396 VSS.n1395 0.7505
R3603 VSS.n1397 VSS.n1328 0.7505
R3604 VSS.n1399 VSS.n1398 0.7505
R3605 VSS.n1400 VSS.n1326 0.7505
R3606 VSS.n1403 VSS.n1402 0.7505
R3607 VSS.n1404 VSS.n1325 0.7505
R3608 VSS.n1406 VSS.n1405 0.7505
R3609 VSS.n1407 VSS.n1324 0.7505
R3610 VSS.n1409 VSS.n1408 0.7505
R3611 VSS.n1410 VSS.n1323 0.7505
R3612 VSS.n1412 VSS.n1411 0.7505
R3613 VSS.n1413 VSS.n1322 0.7505
R3614 VSS.n1415 VSS.n1414 0.7505
R3615 VSS.n1417 VSS.n1416 0.7505
R3616 VSS.n1418 VSS.n1320 0.7505
R3617 VSS.n1420 VSS.n1419 0.7505
R3618 VSS.n1421 VSS.n1319 0.7505
R3619 VSS.n1423 VSS.n1422 0.7505
R3620 VSS.n1424 VSS.n1318 0.7505
R3621 VSS.n1426 VSS.n1425 0.7505
R3622 VSS.n1427 VSS.n1317 0.7505
R3623 VSS.n1429 VSS.n1428 0.7505
R3624 VSS.n1431 VSS.n1315 0.7505
R3625 VSS.n1433 VSS.n1432 0.7505
R3626 VSS.n1434 VSS.n1314 0.7505
R3627 VSS.n1436 VSS.n1435 0.7505
R3628 VSS.n1437 VSS.n1313 0.7505
R3629 VSS.n1439 VSS.n1438 0.7505
R3630 VSS.n1440 VSS.n1312 0.7505
R3631 VSS.n1442 VSS.n1441 0.7505
R3632 VSS.n1443 VSS.n1311 0.7505
R3633 VSS.n1040 VSS.n1039 0.7505
R3634 VSS.n1038 VSS.n894 0.7505
R3635 VSS.n1037 VSS.n1036 0.7505
R3636 VSS.n1035 VSS.n895 0.7505
R3637 VSS.n1034 VSS.n1033 0.7505
R3638 VSS.n1032 VSS.n896 0.7505
R3639 VSS.n1031 VSS.n1030 0.7505
R3640 VSS.n1029 VSS.n897 0.7505
R3641 VSS.n1028 VSS.n1027 0.7505
R3642 VSS.n1026 VSS.n1025 0.7505
R3643 VSS.n1024 VSS.n899 0.7505
R3644 VSS.n1023 VSS.n1022 0.7505
R3645 VSS.n1021 VSS.n900 0.7505
R3646 VSS.n1020 VSS.n1019 0.7505
R3647 VSS.n1018 VSS.n901 0.7505
R3648 VSS.n1017 VSS.n1016 0.7505
R3649 VSS.n1015 VSS.n902 0.7505
R3650 VSS.n1014 VSS.n1013 0.7505
R3651 VSS.n904 VSS.n903 0.7505
R3652 VSS.n973 VSS.n972 0.7505
R3653 VSS.n975 VSS.n974 0.7505
R3654 VSS.n976 VSS.n971 0.7505
R3655 VSS.n978 VSS.n977 0.7505
R3656 VSS.n979 VSS.n970 0.7505
R3657 VSS.n981 VSS.n980 0.7505
R3658 VSS.n982 VSS.n969 0.7505
R3659 VSS.n984 VSS.n983 0.7505
R3660 VSS.n986 VSS.n985 0.7505
R3661 VSS.n987 VSS.n968 0.7505
R3662 VSS.n989 VSS.n988 0.7505
R3663 VSS.n990 VSS.n967 0.7505
R3664 VSS.n992 VSS.n991 0.7505
R3665 VSS.n993 VSS.n966 0.7505
R3666 VSS.n995 VSS.n994 0.7505
R3667 VSS.n996 VSS.n915 0.7505
R3668 VSS.n998 VSS.n997 0.7505
R3669 VSS.n965 VSS.n914 0.7505
R3670 VSS.n964 VSS.n963 0.7505
R3671 VSS.n962 VSS.n916 0.7505
R3672 VSS.n961 VSS.n960 0.7505
R3673 VSS.n959 VSS.n917 0.7505
R3674 VSS.n958 VSS.n957 0.7505
R3675 VSS.n956 VSS.n918 0.7505
R3676 VSS.n955 VSS.n954 0.7505
R3677 VSS.n953 VSS.n919 0.7505
R3678 VSS.n952 VSS.n951 0.7505
R3679 VSS.n921 VSS.n920 0.7505
R3680 VSS.n933 VSS.n932 0.7505
R3681 VSS.n934 VSS.n931 0.7505
R3682 VSS.n936 VSS.n935 0.7505
R3683 VSS.n937 VSS.n930 0.7505
R3684 VSS.n939 VSS.n938 0.7505
R3685 VSS.n940 VSS.n929 0.7505
R3686 VSS.n942 VSS.n941 0.7505
R3687 VSS.n668 VSS.n653 0.7505
R3688 VSS.n667 VSS.n666 0.7505
R3689 VSS.n665 VSS.n654 0.7505
R3690 VSS.n664 VSS.n663 0.7505
R3691 VSS.n662 VSS.n655 0.7505
R3692 VSS.n661 VSS.n660 0.7505
R3693 VSS.n659 VSS.n656 0.7505
R3694 VSS.n658 VSS.n657 0.7505
R3695 VSS.n642 VSS.n641 0.7505
R3696 VSS.n1482 VSS.n1481 0.7505
R3697 VSS.n1483 VSS.n640 0.7505
R3698 VSS.n1485 VSS.n1484 0.7505
R3699 VSS.n1486 VSS.n639 0.7505
R3700 VSS.n1488 VSS.n1487 0.7505
R3701 VSS.n1489 VSS.n638 0.7505
R3702 VSS.n1491 VSS.n1490 0.7505
R3703 VSS.n1492 VSS.n636 0.7505
R3704 VSS.n1494 VSS.n1493 0.7505
R3705 VSS.n1495 VSS.n635 0.7505
R3706 VSS.n1497 VSS.n1496 0.7505
R3707 VSS.n1498 VSS.n634 0.7505
R3708 VSS.n1500 VSS.n1499 0.7505
R3709 VSS.n1501 VSS.n633 0.7505
R3710 VSS.n1503 VSS.n1502 0.7505
R3711 VSS.n1505 VSS.n1504 0.7505
R3712 VSS.n1506 VSS.n632 0.7505
R3713 VSS.n1508 VSS.n1507 0.7505
R3714 VSS.n1510 VSS.n630 0.7505
R3715 VSS.n1512 VSS.n1511 0.7505
R3716 VSS.n1513 VSS.n629 0.7505
R3717 VSS.n1515 VSS.n1514 0.7505
R3718 VSS.n1516 VSS.n628 0.7505
R3719 VSS.n1518 VSS.n1517 0.7505
R3720 VSS.n1519 VSS.n627 0.7505
R3721 VSS.n1521 VSS.n1520 0.7505
R3722 VSS.n1522 VSS.n626 0.7505
R3723 VSS.n1525 VSS.n1524 0.7505
R3724 VSS.n1526 VSS.n625 0.7505
R3725 VSS.n1528 VSS.n1527 0.7505
R3726 VSS.n1529 VSS.n624 0.7505
R3727 VSS.n1531 VSS.n1530 0.7505
R3728 VSS.n1532 VSS.n623 0.7505
R3729 VSS.n1534 VSS.n1533 0.7505
R3730 VSS.n1535 VSS.n622 0.7505
R3731 VSS.n1537 VSS.n1536 0.7505
R3732 VSS.n1539 VSS.n1538 0.7505
R3733 VSS.n1540 VSS.n620 0.7505
R3734 VSS.n1542 VSS.n1541 0.7505
R3735 VSS.n1543 VSS.n619 0.7505
R3736 VSS.n1545 VSS.n1544 0.7505
R3737 VSS.n1546 VSS.n618 0.7505
R3738 VSS.n1548 VSS.n1547 0.7505
R3739 VSS.n1549 VSS.n617 0.7505
R3740 VSS.n1551 VSS.n1550 0.7505
R3741 VSS.n243 VSS.n242 0.7505
R3742 VSS.n244 VSS.n240 0.7505
R3743 VSS.n246 VSS.n245 0.7505
R3744 VSS.n247 VSS.n239 0.7505
R3745 VSS.n249 VSS.n248 0.7505
R3746 VSS.n250 VSS.n238 0.7505
R3747 VSS.n252 VSS.n251 0.7505
R3748 VSS.n253 VSS.n237 0.7505
R3749 VSS.n255 VSS.n254 0.7505
R3750 VSS.n257 VSS.n256 0.7505
R3751 VSS.n258 VSS.n233 0.7505
R3752 VSS.n260 VSS.n259 0.7505
R3753 VSS.n261 VSS.n232 0.7505
R3754 VSS.n263 VSS.n262 0.7505
R3755 VSS.n264 VSS.n231 0.7505
R3756 VSS.n266 VSS.n265 0.7505
R3757 VSS.n267 VSS.n195 0.7505
R3758 VSS.n269 VSS.n268 0.7505
R3759 VSS.n230 VSS.n194 0.7505
R3760 VSS.n229 VSS.n228 0.7505
R3761 VSS.n227 VSS.n196 0.7505
R3762 VSS.n226 VSS.n225 0.7505
R3763 VSS.n224 VSS.n197 0.7505
R3764 VSS.n223 VSS.n222 0.7505
R3765 VSS.n221 VSS.n198 0.7505
R3766 VSS.n220 VSS.n219 0.7505
R3767 VSS.n218 VSS.n199 0.7505
R3768 VSS.n217 VSS.n216 0.7505
R3769 VSS.n214 VSS.n200 0.7505
R3770 VSS.n213 VSS.n212 0.7505
R3771 VSS.n211 VSS.n201 0.7505
R3772 VSS.n210 VSS.n209 0.7505
R3773 VSS.n208 VSS.n202 0.7505
R3774 VSS.n207 VSS.n206 0.7505
R3775 VSS.n205 VSS.n203 0.7505
R3776 VSS.n204 VSS.n172 0.7505
R3777 VSS.n279 VSS.n171 0.7505
R3778 VSS.n281 VSS.n280 0.7505
R3779 VSS.n282 VSS.n170 0.7505
R3780 VSS.n284 VSS.n283 0.7505
R3781 VSS.n285 VSS.n169 0.7505
R3782 VSS.n287 VSS.n286 0.7505
R3783 VSS.n288 VSS.n168 0.7505
R3784 VSS.n290 VSS.n289 0.7505
R3785 VSS.n291 VSS.n166 0.7505
R3786 VSS.n294 VSS.n293 0.7505
R3787 VSS.n295 VSS.n165 0.7505
R3788 VSS.n297 VSS.n296 0.7505
R3789 VSS.n298 VSS.n164 0.7505
R3790 VSS.n300 VSS.n299 0.7505
R3791 VSS.n301 VSS.n163 0.7505
R3792 VSS.n303 VSS.n302 0.7505
R3793 VSS.n304 VSS.n162 0.7505
R3794 VSS.n306 VSS.n305 0.7505
R3795 VSS.n308 VSS.n307 0.7505
R3796 VSS.n309 VSS.n160 0.7505
R3797 VSS.n311 VSS.n310 0.7505
R3798 VSS.n312 VSS.n159 0.7505
R3799 VSS.n314 VSS.n313 0.7505
R3800 VSS.n315 VSS.n158 0.7505
R3801 VSS.n317 VSS.n316 0.7505
R3802 VSS.n318 VSS.n157 0.7505
R3803 VSS.n320 VSS.n319 0.7505
R3804 VSS.n321 VSS.n156 0.7505
R3805 VSS.n323 VSS.n322 0.7505
R3806 VSS.n1145 VSS.n1144 0.743357
R3807 VSS.n1144 VSS.n1102 0.743357
R3808 VSS.n1139 VSS.n1137 0.743357
R3809 VSS.n1139 VSS.n1138 0.743357
R3810 VSS.n877 VSS.n876 0.743357
R3811 VSS.n832 VSS.n831 0.743357
R3812 VSS.n1850 VSS.n1849 0.743357
R3813 VSS.n1851 VSS.n1850 0.743357
R3814 VSS.n1853 VSS.n1852 0.743357
R3815 VSS.n1852 VSS.n1851 0.743357
R3816 VSS.n1239 VSS.n749 0.743357
R3817 VSS.n1244 VSS.n749 0.743357
R3818 VSS.n1823 VSS.n86 0.743357
R3819 VSS.n1828 VSS.n86 0.743357
R3820 VSS.n690 VSS.n688 0.743357
R3821 VSS.t254 VSS.n690 0.743357
R3822 VSS.n1281 VSS.n1280 0.743357
R3823 VSS.n1282 VSS.n1281 0.743357
R3824 VSS.n717 VSS.n692 0.743357
R3825 VSS.n1282 VSS.n692 0.743357
R3826 VSS.n1095 VSS.n1060 0.743357
R3827 VSS.t304 VSS.n1060 0.743357
R3828 VSS.n878 VSS.n877 0.738846
R3829 VSS.n831 VSS.n830 0.738846
R3830 VSS.n1066 VSS.n1065 0.737079
R3831 VSS.n1076 VSS.n1075 0.737079
R3832 VSS.n1095 VSS.n1094 0.731158
R3833 VSS.n1286 VSS.n688 0.731158
R3834 VSS.n876 VSS.n796 0.72353
R3835 VSS.n1854 VSS.n1853 0.72353
R3836 VSS.n1280 VSS.n699 0.72353
R3837 VSS.n833 VSS.n832 0.72353
R3838 VSS.n1884 VSS.n49 0.7196
R3839 VSS.n717 VSS.n686 0.707474
R3840 VSS.n1067 VSS.n1066 0.70629
R3841 VSS.n1075 VSS.n1068 0.70629
R3842 VSS.n1213 VSS.n760 0.70629
R3843 VSS.n767 VSS.n766 0.70629
R3844 VSS.n1849 VSS.n49 0.699184
R3845 VSS.n786 VSS.n784 0.687154
R3846 VSS.n1161 VSS.n1159 0.687154
R3847 VSS.n865 VSS.n812 0.680381
R3848 VSS.n1870 VSS.n1869 0.680381
R3849 VSS.n744 VSS.n743 0.680381
R3850 VSS.n843 VSS.n842 0.673132
R3851 VSS.n873 VSS.n872 0.673132
R3852 VSS.n1269 VSS.n1268 0.673132
R3853 VSS.n1864 VSS.n1863 0.673132
R3854 VSS.n1836 VSS.n1835 0.673132
R3855 VSS.n721 VSS.n707 0.673132
R3856 VSS.n1216 VSS.n1214 0.663658
R3857 VSS.n1212 VSS.n1211 0.663658
R3858 VSS.n1089 VSS.n1088 0.662474
R3859 VSS.n1079 VSS.n1078 0.662474
R3860 VSS.n755 VSS.t204 0.6557
R3861 VSS.n755 VSS.t205 0.6557
R3862 VSS.n92 VSS.t206 0.6557
R3863 VSS.n92 VSS.t208 0.6557
R3864 VSS.n1124 VSS.t196 0.6557
R3865 VSS.n1124 VSS.t197 0.6557
R3866 VSS.n1115 VSS.t198 0.6557
R3867 VSS.n1115 VSS.t200 0.6557
R3868 VSS.n1882 VSS.n1881 0.64925
R3869 VSS.n787 VSS.n780 0.640782
R3870 VSS.n1118 VSS.n1117 0.621026
R3871 VSS.n845 VSS.n844 0.612737
R3872 VSS.n871 VSS.n807 0.612737
R3873 VSS.n1267 VSS.n729 0.612737
R3874 VSS.n1865 VSS.n76 0.612737
R3875 VSS.n724 VSS.n723 0.612737
R3876 VSS.n1209 VSS.n761 0.593789
R3877 VSS.n1223 VSS.n1222 0.593789
R3878 VSS.n1826 VSS.n1825 0.578395
R3879 VSS.n1242 VSS.n1241 0.578395
R3880 VSS.n1123 VSS.n1122 0.578395
R3881 VSS.n1148 VSS.n1147 0.578395
R3882 VSS.n1794 VSS.n114 0.5783
R3883 VSS.n426 VSS.n425 0.5783
R3884 VSS.n1563 VSS.n1562 0.5783
R3885 VSS.n1295 VSS.n1294 0.5783
R3886 VSS.n889 VSS.n888 0.5783
R3887 VSS.n1464 VSS.n1463 0.5783
R3888 VSS.n1803 VSS.n1802 0.5783
R3889 VSS.n607 VSS.n606 0.5765
R3890 VSS.n1452 VSS.n1451 0.5765
R3891 VSS.n1047 VSS.n1046 0.5765
R3892 VSS.n675 VSS.n674 0.5765
R3893 VSS.n1793 VSS.n1792 0.57605
R3894 VSS.n420 VSS.n419 0.57605
R3895 VSS.n1804 VSS.n107 0.57605
R3896 VSS.n1129 VSS.t44 0.5675
R3897 VSS.n1200 VSS.t31 0.5675
R3898 VSS.n96 VSS.t165 0.5675
R3899 VSS.n1810 VSS.t168 0.5675
R3900 VSS.n1834 VSS.n51 0.553526
R3901 VSS.n1231 VSS.n756 0.552342
R3902 VSS.n1231 VSS.n93 0.552342
R3903 VSS.n1127 VSS.n1126 0.552342
R3904 VSS.n1126 VSS.n1116 0.552342
R3905 VSS.n853 VSS.n852 0.541684
R3906 VSS.n1259 VSS.n1251 0.541684
R3907 VSS.n1170 VSS.n1169 0.531026
R3908 VSS.n1185 VSS.n1184 0.531026
R3909 VSS.n1824 VSS.n1823 0.529842
R3910 VSS.n1240 VSS.n1239 0.529842
R3911 VSS.n1239 VSS.n1238 0.529842
R3912 VSS.n1137 VSS.n1128 0.529842
R3913 VSS.n1146 VSS.n1145 0.529842
R3914 VSS.n1145 VSS.n1118 0.529842
R3915 VSS.n860 VSS.n823 0.5205
R3916 VSS.n860 VSS.n859 0.5205
R3917 VSS.n808 VSS.n805 0.5205
R3918 VSS.n868 VSS.n808 0.5205
R3919 VSS.n857 VSS.n856 0.5205
R3920 VSS.n859 VSS.n857 0.5205
R3921 VSS.n869 VSS.n867 0.5205
R3922 VSS.n869 VSS.n868 0.5205
R3923 VSS.n1248 VSS.n60 0.5205
R3924 VSS.n1874 VSS.n60 0.5205
R3925 VSS.n1873 VSS.n1872 0.5205
R3926 VSS.n1874 VSS.n1873 0.5205
R3927 VSS.n77 VSS.n74 0.5205
R3928 VSS.n1831 VSS.n74 0.5205
R3929 VSS.n1833 VSS.n1832 0.5205
R3930 VSS.n1832 VSS.n1831 0.5205
R3931 VSS.n1270 VSS.n720 0.5205
R3932 VSS.n1274 VSS.n720 0.5205
R3933 VSS.n1273 VSS.n1272 0.5205
R3934 VSS.n1274 VSS.n1273 0.5205
R3935 VSS.n741 VSS.n730 0.5205
R3936 VSS.n748 VSS.n730 0.5205
R3937 VSS.n747 VSS.n746 0.5205
R3938 VSS.n748 VSS.n747 0.5205
R3939 VSS.n1094 VSS.n1061 0.51816
R3940 VSS.n1286 VSS.n687 0.51816
R3941 VSS.n1055 VSS.n768 0.50185
R3942 VSS.n849 VSS.n847 0.494316
R3943 VSS.n1256 VSS.n1255 0.494316
R3944 VSS.n1878 VSS.n1877 0.494316
R3945 VSS.n1825 VSS.n1824 0.493132
R3946 VSS.n1241 VSS.n1240 0.493132
R3947 VSS.n1128 VSS.n1123 0.493132
R3948 VSS.n1147 VSS.n1146 0.493132
R3949 VSS.n1136 VSS.n1133 0.491947
R3950 VSS.n1254 VSS.n1253 0.487211
R3951 VSS.n1174 VSS.n1173 0.483658
R3952 VSS.n1177 VSS.n1176 0.483658
R3953 VSS.n1881 VSS.n52 0.470632
R3954 VSS.n839 VSS.n838 0.462342
R3955 VSS.n835 VSS.n834 0.462342
R3956 VSS.n799 VSS.n798 0.462342
R3957 VSS.n803 VSS.n802 0.462342
R3958 VSS.n1856 VSS.n1855 0.462342
R3959 VSS.n1860 VSS.n1859 0.462342
R3960 VSS.n1845 VSS.n1844 0.462342
R3961 VSS.n1841 VSS.n1840 0.462342
R3962 VSS.n701 VSS.n700 0.462342
R3963 VSS.n705 VSS.n704 0.462342
R3964 VSS.n714 VSS.n713 0.462342
R3965 VSS.n710 VSS.n709 0.462342
R3966 VSS.n852 VSS.n790 0.458789
R3967 VSS.n1260 VSS.n1259 0.458789
R3968 VSS.n882 VSS.n881 0.446947
R3969 VSS.n1057 VSS.n880 0.446947
R3970 VSS.n1169 VSS.n1153 0.445763
R3971 VSS.n1058 VSS.n1057 0.444579
R3972 VSS.n882 VSS.n683 0.444579
R3973 VSS.n854 VSS.n845 0.439842
R3974 VSS.n846 VSS.n807 0.439842
R3975 VSS.n739 VSS.n729 0.439842
R3976 VSS.n1250 VSS.n76 0.439842
R3977 VSS.n723 VSS.n55 0.439842
R3978 VSS.t254 VSS.n693 0.434333
R3979 VSS.n693 VSS.n687 0.434333
R3980 VSS.t304 VSS.n1062 0.434333
R3981 VSS.n1062 VSS.n1061 0.434333
R3982 VSS.n1210 VSS.n762 0.433833
R3983 VSS.n883 VSS.n762 0.433833
R3984 VSS.n763 VSS.n759 0.433833
R3985 VSS.n764 VSS.n763 0.433833
R3986 VSS.n847 VSS.n815 0.433833
R3987 VSS.n815 VSS.n793 0.433833
R3988 VSS.n853 VSS.n816 0.433833
R3989 VSS.n858 VSS.n816 0.433833
R3990 VSS.n1877 VSS.n1876 0.433833
R3991 VSS.n1876 VSS.n1875 0.433833
R3992 VSS.n59 VSS.n52 0.433833
R3993 VSS.n1875 VSS.n59 0.433833
R3994 VSS.n1255 VSS.n734 0.433833
R3995 VSS.n1245 VSS.n734 0.433833
R3996 VSS.n1251 VSS.n1246 0.433833
R3997 VSS.n1246 VSS.n1245 0.433833
R3998 VSS.n1090 VSS.n1089 0.433833
R3999 VSS.n1091 VSS.n1090 0.433833
R4000 VSS.n1078 VSS.n1077 0.433833
R4001 VSS.n1077 VSS.n694 0.433833
R4002 VSS.n1134 VSS.n779 0.420675
R4003 VSS.n813 VSS.t175 0.41
R4004 VSS.n813 VSS.t177 0.41
R4005 VSS.n811 VSS.t181 0.41
R4006 VSS.n811 VSS.t179 0.41
R4007 VSS.n64 VSS.t186 0.41
R4008 VSS.n64 VSS.t182 0.41
R4009 VSS.n66 VSS.t185 0.41
R4010 VSS.n66 VSS.t184 0.41
R4011 VSS.n738 VSS.t187 0.41
R4012 VSS.n738 VSS.t183 0.41
R4013 VSS.n737 VSS.t189 0.41
R4014 VSS.n737 VSS.t188 0.41
R4015 VSS.n1238 VSS.n1228 0.408529
R4016 VSS.n1822 VSS.n94 0.407868
R4017 VSS.n1136 VSS.n1135 0.407868
R4018 VSS.n1291 VSS.n1290 0.403035
R4019 VSS.n1209 VSS.n1208 0.398395
R4020 VSS.n1163 VSS.n1161 0.393658
R4021 VSS.n1165 VSS.n1163 0.393658
R4022 VSS.n1167 VSS.n1165 0.393658
R4023 VSS.n1182 VSS.n1181 0.393658
R4024 VSS.n784 VSS.n783 0.393658
R4025 VSS.n1226 VSS.n1225 0.388921
R4026 VSS.n1225 VSS.n757 0.384184
R4027 VSS.n840 VSS.n839 0.381839
R4028 VSS.n804 VSS.n803 0.381839
R4029 VSS.n1861 VSS.n1860 0.381839
R4030 VSS.n1846 VSS.n1845 0.381839
R4031 VSS.n1840 VSS.n1839 0.381839
R4032 VSS.n706 VSS.n705 0.381839
R4033 VSS.n715 VSS.n714 0.381839
R4034 VSS.n709 VSS.n708 0.381839
R4035 VSS.n1744 VSS.n1738 0.381628
R4036 VSS.n1800 VSS.n109 0.381628
R4037 VSS.n473 VSS.n472 0.380714
R4038 VSS.n1446 VSS.n1445 0.380714
R4039 VSS.n928 VSS.n927 0.380714
R4040 VSS.n1465 VSS.n616 0.380714
R4041 VSS.n1194 VSS.n778 0.368414
R4042 VSS.n836 VSS.n835 0.365237
R4043 VSS.n838 VSS.n837 0.365237
R4044 VSS.n834 VSS.n833 0.365237
R4045 VSS.n798 VSS.n796 0.365237
R4046 VSS.n800 VSS.n799 0.365237
R4047 VSS.n802 VSS.n801 0.365237
R4048 VSS.n1855 VSS.n1854 0.365237
R4049 VSS.n1859 VSS.n1858 0.365237
R4050 VSS.n1857 VSS.n1856 0.365237
R4051 VSS.n1844 VSS.n1843 0.365237
R4052 VSS.n1842 VSS.n1841 0.365237
R4053 VSS.n700 VSS.n699 0.365237
R4054 VSS.n702 VSS.n701 0.365237
R4055 VSS.n704 VSS.n703 0.365237
R4056 VSS.n711 VSS.n710 0.365237
R4057 VSS.n713 VSS.n712 0.365237
R4058 VSS.n581 VSS.n411 0.362079
R4059 VSS.n1187 VSS.n1186 0.347167
R4060 VSS.n1188 VSS.n1187 0.347167
R4061 VSS.n871 VSS.n870 0.347167
R4062 VSS.n870 VSS.n788 0.347167
R4063 VSS.n862 VSS.n812 0.347167
R4064 VSS.n863 VSS.n862 0.347167
R4065 VSS.n844 VSS.n820 0.347167
R4066 VSS.n820 VSS.n680 0.347167
R4067 VSS.n1834 VSS.n61 0.347167
R4068 VSS.n1867 VSS.n61 0.347167
R4069 VSS.n1869 VSS.n1868 0.347167
R4070 VSS.n1868 VSS.n1867 0.347167
R4071 VSS.n1866 VSS.n1865 0.347167
R4072 VSS.n1867 VSS.n1866 0.347167
R4073 VSS.n725 VSS.n724 0.347167
R4074 VSS.n1265 VSS.n725 0.347167
R4075 VSS.n743 VSS.n732 0.347167
R4076 VSS.n1265 VSS.n732 0.347167
R4077 VSS.n1267 VSS.n1266 0.347167
R4078 VSS.n1266 VSS.n1265 0.347167
R4079 VSS.n1071 VSS.n1063 0.347167
R4080 VSS.n1072 VSS.n1063 0.347167
R4081 VSS.n1086 VSS.n1064 0.347167
R4082 VSS.n1072 VSS.n1064 0.347167
R4083 VSS.n1256 VSS.n1247 0.345311
R4084 VSS.n845 VSS.n824 0.34475
R4085 VSS.n807 VSS.n806 0.34475
R4086 VSS.n850 VSS.n849 0.34475
R4087 VSS.n729 VSS.n728 0.34475
R4088 VSS.n76 VSS.n75 0.34475
R4089 VSS.n1257 VSS.n1256 0.34475
R4090 VSS.n723 VSS.n722 0.34475
R4091 VSS.n1449 VSS.n1297 0.338901
R4092 VSS.n1044 VSS.n891 0.338901
R4093 VSS.n672 VSS.n670 0.338901
R4094 VSS.n1881 VSS.n1880 0.3305
R4095 VSS.n1241 VSS.n754 0.32935
R4096 VSS.n1825 VSS.n91 0.32935
R4097 VSS.n1147 VSS.n1114 0.32935
R4098 VSS.n1123 VSS.n1121 0.32935
R4099 VSS.n1069 VSS.t194 0.3281
R4100 VSS.n1069 VSS.t202 0.3281
R4101 VSS.n1215 VSS.t279 0.3281
R4102 VSS.n1215 VSS.t275 0.3281
R4103 VSS.n765 VSS.t273 0.3281
R4104 VSS.n765 VSS.t277 0.3281
R4105 VSS.n1881 VSS.n53 0.321627
R4106 VSS.n1745 VSS.n1744 0.318348
R4107 VSS.n474 VSS.n473 0.318348
R4108 VSS.n1564 VSS.n411 0.318348
R4109 VSS.n1446 VSS.n1310 0.318348
R4110 VSS.n927 VSS.n922 0.318348
R4111 VSS.n1466 VSS.n1465 0.318348
R4112 VSS.n1801 VSS.n1800 0.318348
R4113 VSS.n1217 VSS.n1216 0.3155
R4114 VSS VSS.n1212 0.314316
R4115 VSS.n1184 VSS.n1108 0.306382
R4116 VSS.n1108 VSS.n1107 0.306382
R4117 VSS.n1170 VSS.n1105 0.306382
R4118 VSS.n1110 VSS.n1105 0.306382
R4119 VSS.n1148 VSS.n1112 0.306382
R4120 VSS.n1112 VSS.n1102 0.306382
R4121 VSS.n1122 VSS.n1111 0.306382
R4122 VSS.n1138 VSS.n1111 0.306382
R4123 VSS.n1243 VSS.n1242 0.306382
R4124 VSS.n1244 VSS.n1243 0.306382
R4125 VSS.n1827 VSS.n1826 0.306382
R4126 VSS.n1828 VSS.n1827 0.306382
R4127 VSS.n822 VSS.n821 0.302706
R4128 VSS.n84 VSS.n68 0.302706
R4129 VSS.n1271 VSS.n727 0.302706
R4130 VSS.n1253 VSS.n1252 0.302
R4131 VSS.n1169 VSS.n1168 0.2885
R4132 VSS.n1185 VSS.n1154 0.2885
R4133 VSS.n1879 VSS.n1878 0.2885
R4134 VSS.n873 VSS.n805 0.288263
R4135 VSS.n842 VSS.n823 0.288263
R4136 VSS.n1836 VSS.n1833 0.288263
R4137 VSS.n1863 VSS.n77 0.288263
R4138 VSS.n1272 VSS.n707 0.288263
R4139 VSS.n1270 VSS.n1269 0.288263
R4140 VSS.n844 VSS.n843 0.281158
R4141 VSS.n872 VSS.n871 0.281158
R4142 VSS.n1268 VSS.n1267 0.281158
R4143 VSS.n1865 VSS.n1864 0.281158
R4144 VSS.n1835 VSS.n1834 0.281158
R4145 VSS.n724 VSS.n721 0.281158
R4146 VSS.n1822 VSS 0.271684
R4147 VSS.n1791 VSS.n1790 0.2705
R4148 VSS.n605 VSS.n604 0.2705
R4149 VSS.n418 VSS.n417 0.2705
R4150 VSS.n1450 VSS.n1449 0.2705
R4151 VSS.n1045 VSS.n1044 0.2705
R4152 VSS.n673 VSS.n672 0.2705
R4153 VSS.n181 VSS.n180 0.2705
R4154 VSS VSS.n1821 0.265763
R4155 VSS.n1790 VSS.n116 0.264935
R4156 VSS.n604 VSS.n428 0.264935
R4157 VSS.n417 VSS.n326 0.264935
R4158 VSS.n181 VSS.n155 0.264935
R4159 VSS.n1218 VSS.n1217 0.248119
R4160 VSS.n1219 VSS.n1218 0.248119
R4161 VSS.n1221 VSS.n1220 0.248119
R4162 VSS.n1220 VSS.n1219 0.248119
R4163 VSS.n865 VSS.n864 0.248119
R4164 VSS.n864 VSS.n863 0.248119
R4165 VSS.n819 VSS.n818 0.248119
R4166 VSS.n863 VSS.n819 0.248119
R4167 VSS.n744 VSS.n56 0.248119
R4168 VSS.n750 VSS.n56 0.248119
R4169 VSS.n71 VSS.n57 0.248119
R4170 VSS.n1230 VSS.n57 0.248119
R4171 VSS.n1263 VSS.n1262 0.248119
R4172 VSS.n1264 VSS.n1263 0.248119
R4173 VSS.n1870 VSS.n65 0.248119
R4174 VSS.n65 VSS.n58 0.248119
R4175 VSS.n852 VSS.n851 0.24575
R4176 VSS.n1259 VSS.n1258 0.24575
R4177 VSS.n1175 VSS.n1174 0.242079
R4178 VSS.n1176 VSS.n1175 0.242079
R4179 VSS.n1823 VSS.n1822 0.240895
R4180 VSS.n1137 VSS.n1136 0.240895
R4181 VSS.n849 VSS.n848 0.237342
R4182 VSS.n1878 VSS.n54 0.237342
R4183 VSS.n1568 VSS.n1567 0.236864
R4184 VSS.n1567 VSS.t281 0.236864
R4185 VSS.n1598 VSS.n1597 0.236864
R4186 VSS.t282 VSS.n1598 0.236864
R4187 VSS.n1605 VSS.n1604 0.236864
R4188 VSS.n1604 VSS.t283 0.236864
R4189 VSS.n413 VSS.n332 0.236864
R4190 VSS.t284 VSS.n413 0.236864
R4191 VSS.n417 VSS.n416 0.236864
R4192 VSS.n416 VSS.n415 0.236864
R4193 VSS.n348 VSS.n338 0.236864
R4194 VSS.n348 VSS.n346 0.236864
R4195 VSS.n353 VSS.n352 0.236864
R4196 VSS.n352 VSS.n347 0.236864
R4197 VSS.n408 VSS.n407 0.236864
R4198 VSS.n409 VSS.n408 0.236864
R4199 VSS.n411 VSS.n406 0.236864
R4200 VSS.n422 VSS.n406 0.236864
R4201 VSS.n1566 VSS.n1565 0.236864
R4202 VSS.t281 VSS.n1566 0.236864
R4203 VSS.n1600 VSS.n1599 0.236864
R4204 VSS.n1599 VSS.t282 0.236864
R4205 VSS.n1603 VSS.n1602 0.236864
R4206 VSS.t283 VSS.n1603 0.236864
R4207 VSS.n414 VSS.n412 0.236864
R4208 VSS.t284 VSS.n414 0.236864
R4209 VSS.n473 VSS.n455 0.236864
R4210 VSS.n455 VSS.t301 0.236864
R4211 VSS.n476 VSS.n475 0.236864
R4212 VSS.n476 VSS.n357 0.236864
R4213 VSS.n471 VSS.n470 0.236864
R4214 VSS.n470 VSS.n410 0.236864
R4215 VSS.n479 VSS.n478 0.236864
R4216 VSS.n478 VSS.t301 0.236864
R4217 VSS.n454 VSS.n441 0.236864
R4218 VSS.n454 VSS.n357 0.236864
R4219 VSS.n547 VSS.n546 0.236864
R4220 VSS.n547 VSS.n410 0.236864
R4221 VSS.n550 VSS.n549 0.236864
R4222 VSS.n549 VSS.t301 0.236864
R4223 VSS.n553 VSS.n552 0.236864
R4224 VSS.n553 VSS.n357 0.236864
R4225 VSS.n517 VSS.n443 0.236864
R4226 VSS.n443 VSS.n410 0.236864
R4227 VSS.n556 VSS.n555 0.236864
R4228 VSS.n555 VSS.t301 0.236864
R4229 VSS.n429 VSS.n427 0.236864
R4230 VSS.n429 VSS.n357 0.236864
R4231 VSS.n602 VSS.n601 0.236864
R4232 VSS.n602 VSS.n410 0.236864
R4233 VSS.n604 VSS.n603 0.236864
R4234 VSS.n603 VSS.t301 0.236864
R4235 VSS.n927 VSS.n923 0.236864
R4236 VSS.n924 VSS.n923 0.236864
R4237 VSS.n944 VSS.n943 0.236864
R4238 VSS.t308 VSS.n944 0.236864
R4239 VSS.n949 VSS.n948 0.236864
R4240 VSS.n1000 VSS.n999 0.236864
R4241 VSS.t309 VSS.n1000 0.236864
R4242 VSS.n1004 VSS.n1003 0.236864
R4243 VSS.n1012 VSS.n1011 0.236864
R4244 VSS.n1011 VSS.t310 0.236864
R4245 VSS.n1009 VSS.n1008 0.236864
R4246 VSS.n1042 VSS.n1041 0.236864
R4247 VSS.n1042 VSS.t311 0.236864
R4248 VSS.n1044 VSS.n1043 0.236864
R4249 VSS.n1043 VSS.n677 0.236864
R4250 VSS.n772 VSS.n770 0.236864
R4251 VSS.n774 VSS.n772 0.236864
R4252 VSS.n1132 VSS.n773 0.236864
R4253 VSS.n946 VSS.n945 0.236864
R4254 VSS.n945 VSS.t308 0.236864
R4255 VSS.n1001 VSS.n909 0.236864
R4256 VSS.n1001 VSS.t309 0.236864
R4257 VSS.n1006 VSS.n907 0.236864
R4258 VSS.t310 VSS.n907 0.236864
R4259 VSS.n892 VSS.n890 0.236864
R4260 VSS.n892 VSS.t311 0.236864
R4261 VSS.n1465 VSS.n614 0.236864
R4262 VSS.n614 VSS.t306 0.236864
R4263 VSS.n1473 VSS.n1472 0.236864
R4264 VSS.n1474 VSS.n1473 0.236864
R4265 VSS.n1553 VSS.n1552 0.236864
R4266 VSS.n1554 VSS.n1553 0.236864
R4267 VSS.n1468 VSS.n1467 0.236864
R4268 VSS.n1467 VSS.t306 0.236864
R4269 VSS.n1470 VSS.n650 0.236864
R4270 VSS.n1474 VSS.n650 0.236864
R4271 VSS.n1523 VSS.n611 0.236864
R4272 VSS.n1554 VSS.n611 0.236864
R4273 VSS.n646 VSS.n631 0.236864
R4274 VSS.n646 VSS.t306 0.236864
R4275 VSS.n1475 VSS.n648 0.236864
R4276 VSS.n1475 VSS.n1474 0.236864
R4277 VSS.n637 VSS.n613 0.236864
R4278 VSS.n1554 VSS.n613 0.236864
R4279 VSS.n1479 VSS.n1478 0.236864
R4280 VSS.n1478 VSS.t306 0.236864
R4281 VSS.n652 VSS.n644 0.236864
R4282 VSS.n1474 VSS.n644 0.236864
R4283 VSS.n669 VSS.n612 0.236864
R4284 VSS.n1554 VSS.n612 0.236864
R4285 VSS.n672 VSS.n671 0.236864
R4286 VSS.n671 VSS.t306 0.236864
R4287 VSS.n1447 VSS.n1446 0.236864
R4288 VSS.t302 VSS.n1447 0.236864
R4289 VSS.n1338 VSS.n1308 0.236864
R4290 VSS.n1308 VSS.n1303 0.236864
R4291 VSS.n1444 VSS.n1309 0.236864
R4292 VSS.n1309 VSS.n1304 0.236864
R4293 VSS.n1316 VSS.n1307 0.236864
R4294 VSS.t302 VSS.n1307 0.236864
R4295 VSS.n1341 VSS.n1340 0.236864
R4296 VSS.n1341 VSS.n1303 0.236864
R4297 VSS.n1383 VSS.n1321 0.236864
R4298 VSS.n1383 VSS.n1304 0.236864
R4299 VSS.n1327 VSS.n1306 0.236864
R4300 VSS.t302 VSS.n1306 0.236864
R4301 VSS.n1345 VSS.n1344 0.236864
R4302 VSS.n1344 VSS.n1303 0.236864
R4303 VSS.n1387 VSS.n1386 0.236864
R4304 VSS.n1386 VSS.n1304 0.236864
R4305 VSS.n1347 VSS.n1305 0.236864
R4306 VSS.t302 VSS.n1305 0.236864
R4307 VSS.n1298 VSS.n1296 0.236864
R4308 VSS.n1303 VSS.n1298 0.236864
R4309 VSS.n1353 VSS.n1299 0.236864
R4310 VSS.n1304 VSS.n1299 0.236864
R4311 VSS.n1449 VSS.n1448 0.236864
R4312 VSS.n1448 VSS.t302 0.236864
R4313 VSS.n98 VSS.n95 0.236864
R4314 VSS.n98 VSS.n87 0.236864
R4315 VSS.n1812 VSS.n99 0.236864
R4316 VSS.n104 VSS.n99 0.236864
R4317 VSS.n1749 VSS.n1748 0.236864
R4318 VSS.n1748 VSS.t316 0.236864
R4319 VSS.n1779 VSS.n1778 0.236864
R4320 VSS.t317 VSS.n1779 0.236864
R4321 VSS.n1700 VSS.n1699 0.236864
R4322 VSS.n1699 VSS.t318 0.236864
R4323 VSS.n1670 VSS.n117 0.236864
R4324 VSS.t319 VSS.n117 0.236864
R4325 VSS.n1790 VSS.n1789 0.236864
R4326 VSS.n1789 VSS.n1788 0.236864
R4327 VSS.n1786 VSS.n1785 0.236864
R4328 VSS.n1787 VSS.n1786 0.236864
R4329 VSS.n1713 VSS.n124 0.236864
R4330 VSS.n127 VSS.n124 0.236864
R4331 VSS.n1742 VSS.n1741 0.236864
R4332 VSS.n1741 VSS.n128 0.236864
R4333 VSS.n1744 VSS.n1739 0.236864
R4334 VSS.n1740 VSS.n1739 0.236864
R4335 VSS.n1747 VSS.n1746 0.236864
R4336 VSS.t316 VSS.n1747 0.236864
R4337 VSS.n1780 VSS.n126 0.236864
R4338 VSS.n1780 VSS.t317 0.236864
R4339 VSS.n1783 VSS.n1782 0.236864
R4340 VSS.n1782 VSS.t318 0.236864
R4341 VSS.n118 VSS.n115 0.236864
R4342 VSS.t319 VSS.n118 0.236864
R4343 VSS.n189 VSS.n188 0.236864
R4344 VSS.n188 VSS.n176 0.236864
R4345 VSS.n177 VSS.n167 0.236864
R4346 VSS.n177 VSS.n175 0.236864
R4347 VSS.n235 VSS.n234 0.236864
R4348 VSS.n234 VSS.n192 0.236864
R4349 VSS.n111 VSS.n108 0.236864
R4350 VSS.t312 VSS.n111 0.236864
R4351 VSS.n273 VSS.n272 0.236864
R4352 VSS.n272 VSS.t313 0.236864
R4353 VSS.n276 VSS.n275 0.236864
R4354 VSS.t314 VSS.n276 0.236864
R4355 VSS.n186 VSS.n185 0.236864
R4356 VSS.n185 VSS.t315 0.236864
R4357 VSS.n1800 VSS.n1799 0.236864
R4358 VSS.n1799 VSS.n1798 0.236864
R4359 VSS.n182 VSS.n181 0.236864
R4360 VSS.n183 VSS.n182 0.236864
R4361 VSS.n241 VSS.n110 0.236864
R4362 VSS.t312 VSS.n110 0.236864
R4363 VSS.n271 VSS.n270 0.236864
R4364 VSS.t313 VSS.n271 0.236864
R4365 VSS.n278 VSS.n277 0.236864
R4366 VSS.n277 VSS.t314 0.236864
R4367 VSS.n184 VSS.n161 0.236864
R4368 VSS.t315 VSS.n184 0.236864
R4369 VSS.n1262 VSS.n1247 0.232038
R4370 VSS.n71 VSS.n53 0.232038
R4371 VSS.t27 VSS.n1283 0.230589
R4372 VSS.n827 VSS.n795 0.226587
R4373 VSS.n863 VSS.n795 0.226587
R4374 VSS.n817 VSS.n797 0.226587
R4375 VSS.n863 VSS.n817 0.226587
R4376 VSS.n1829 VSS.n78 0.226587
R4377 VSS.n1830 VSS.n1829 0.226587
R4378 VSS.n1837 VSS.n82 0.226587
R4379 VSS.n103 VSS.n82 0.226587
R4380 VSS.n697 VSS.n695 0.226587
R4381 VSS.n1073 VSS.n695 0.226587
R4382 VSS.n1277 VSS.n1276 0.226587
R4383 VSS.n1276 VSS.n1275 0.226587
R4384 VSS.n848 VSS.n789 0.220602
R4385 VSS VSS.n1937 0.2174
R4386 VSS.n875 VSS.n794 0.217167
R4387 VSS.n829 VSS.n825 0.217167
R4388 VSS.n1848 VSS.n83 0.217167
R4389 VSS.t125 VSS.n83 0.217167
R4390 VSS.n81 VSS.n79 0.217167
R4391 VSS.t125 VSS.n81 0.217167
R4392 VSS.n1279 VSS.n696 0.217167
R4393 VSS.t93 VSS.n696 0.217167
R4394 VSS.n719 VSS.n718 0.217167
R4395 VSS.t93 VSS.n719 0.217167
R4396 VSS.n830 VSS.n829 0.216205
R4397 VSS.n878 VSS.n794 0.216205
R4398 VSS.n1054 VSS.n1053 0.212488
R4399 VSS.n1821 VSS.n1820 0.208921
R4400 VSS.n1562 VSS.n1561 0.2005
R4401 VSS.n1561 VSS.n1560 0.2005
R4402 VSS.n425 VSS.n424 0.2005
R4403 VSS.n1294 VSS.n1293 0.2005
R4404 VSS.n1463 VSS.n1462 0.2005
R4405 VSS.n888 VSS.n887 0.2005
R4406 VSS.n1048 VSS.n1047 0.2005
R4407 VSS.n1049 VSS.n1048 0.2005
R4408 VSS.n676 VSS.n675 0.2005
R4409 VSS.n1458 VSS.n676 0.2005
R4410 VSS.n608 VSS.n607 0.2005
R4411 VSS.n421 VSS.n420 0.2005
R4412 VSS.n1301 VSS.n421 0.2005
R4413 VSS.n1453 VSS.n1452 0.2005
R4414 VSS.n1454 VSS.n1453 0.2005
R4415 VSS.n1793 VSS.n113 0.2005
R4416 VSS.n113 VSS.n85 0.2005
R4417 VSS.n1795 VSS.n1794 0.2005
R4418 VSS.n1796 VSS.n1795 0.2005
R4419 VSS.n1803 VSS.n106 0.2005
R4420 VSS.n106 VSS.n102 0.2005
R4421 VSS.n1805 VSS.n1804 0.2005
R4422 VSS.n1806 VSS.n1805 0.2005
R4423 VSS.n783 VSS.n684 0.199447
R4424 VSS.n792 VSS 0.198255
R4425 VSS.n1261 VSS 0.198255
R4426 VSS.n72 VSS 0.198255
R4427 VSS.n1193 VSS.n1192 0.194822
R4428 VSS.n1287 VSS 0.187925
R4429 VSS.n1237 VSS.n1236 0.180168
R4430 VSS.n1229 VSS.n94 0.180168
R4431 VSS.n1141 VSS.n1140 0.180168
R4432 VSS.n1135 VSS.n1134 0.180168
R4433 VSS.n1288 VSS.n686 0.166727
R4434 VSS.n1203 VSS.n1202 0.163921
R4435 VSS.n1172 VSS.n1171 0.163921
R4436 VSS.n1183 VSS.n1178 0.163921
R4437 VSS.n1814 VSS.n1813 0.163921
R4438 VSS.n1088 VSS.n1087 0.163921
R4439 VSS.n1085 VSS.n1079 0.163921
R4440 VSS.n325 VSS.n324 0.159092
R4441 VSS.n1653 VSS.n1652 0.158864
R4442 VSS.n693 VSS.n689 0.155762
R4443 VSS.n1062 VSS.n1059 0.155762
R4444 VSS.t90 VSS.n119 0.153892
R4445 VSS.n1151 VSS.n1150 0.153441
R4446 VSS.n1152 VSS.n1151 0.153441
R4447 VSS.n1126 VSS.n1125 0.153441
R4448 VSS.n1125 VSS.t215 0.153441
R4449 VSS.n1143 VSS.n1142 0.153441
R4450 VSS.n1143 VSS.t215 0.153441
R4451 VSS.n752 VSS.n88 0.153441
R4452 VSS.n88 VSS.n70 0.153441
R4453 VSS.n1232 VSS.n1231 0.153441
R4454 VSS.n1233 VSS.n1232 0.153441
R4455 VSS.n1235 VSS.n1234 0.153441
R4456 VSS.n1234 VSS.n1233 0.153441
R4457 VSS.n1171 VSS.n1167 0.152079
R4458 VSS.n1183 VSS.n1182 0.152079
R4459 VSS.n97 VSS.n50 0.1355
R4460 VSS.n1838 VSS.n49 0.130763
R4461 VSS.n818 VSS.n789 0.129684
R4462 VSS.n818 VSS.n792 0.129684
R4463 VSS.n1262 VSS.n1261 0.129684
R4464 VSS.n72 VSS.n71 0.129684
R4465 VSS.n1195 VSS.n769 0.127329
R4466 VSS.n1196 VSS.n1195 0.127329
R4467 VSS.n1198 VSS.n1197 0.127329
R4468 VSS.n1197 VSS.n1196 0.127329
R4469 VSS.n1816 VSS.n1815 0.127329
R4470 VSS.n1817 VSS.n1816 0.127329
R4471 VSS.n1819 VSS.n1818 0.127329
R4472 VSS.n1818 VSS.n1817 0.127329
R4473 VSS.n1071 VSS.n1070 0.121446
R4474 VSS.n1074 VSS.n1071 0.121446
R4475 VSS.n581 VSS.n580 0.121315
R4476 VSS.n1202 VSS.n1201 0.118921
R4477 VSS.n1133 VSS.n771 0.118921
R4478 VSS.n1131 VSS.n1130 0.118921
R4479 VSS.n101 VSS.n100 0.118921
R4480 VSS.n1813 VSS.n1811 0.118921
R4481 VSS.n1088 VSS.n1067 0.118921
R4482 VSS.n1079 VSS.n1068 0.118921
R4483 VSS.n1238 VSS.n1237 0.118921
R4484 VSS.n1140 VSS.n1118 0.118921
R4485 VSS.n1222 VSS.n760 0.118921
R4486 VSS.n766 VSS.n761 0.118921
R4487 VSS.n1253 VSS.n51 0.107079
R4488 VSS.n1181 VSS.n684 0.104711
R4489 VSS.n472 VSS.n456 0.101527
R4490 VSS.n1445 VSS.n1311 0.101527
R4491 VSS.n941 VSS.n928 0.101527
R4492 VSS.n1550 VSS.n616 0.101527
R4493 VSS.n243 VSS.n109 0.101507
R4494 VSS.n1751 VSS.n1738 0.101507
R4495 VSS.n867 VSS.n866 0.0993344
R4496 VSS.n1872 VSS.n1871 0.0993344
R4497 VSS.n742 VSS.n741 0.0993344
R4498 VSS.n1355 VSS.n1297 0.097752
R4499 VSS.n1039 VSS.n891 0.097752
R4500 VSS.n670 VSS.n653 0.097752
R4501 VSS.n1191 VSS.n1190 0.0967963
R4502 VSS.n1190 VSS.n1189 0.0967963
R4503 VSS.n1175 VSS.n1103 0.0967963
R4504 VSS.n1189 VSS.n1103 0.0967963
R4505 VSS.n865 VSS.n814 0.0913282
R4506 VSS.n1870 VSS.n67 0.0913282
R4507 VSS.n745 VSS.n744 0.0913282
R4508 VSS.n856 VSS.n855 0.0910521
R4509 VSS.n1249 VSS.n1248 0.0910521
R4510 VSS.n746 VSS.n736 0.0910521
R4511 VSS.n856 VSS.n814 0.0855307
R4512 VSS.n1248 VSS.n67 0.0855307
R4513 VSS.n746 VSS.n745 0.0855307
R4514 VSS.n842 VSS.n841 0.0816765
R4515 VSS.n874 VSS.n873 0.0816765
R4516 VSS.n1863 VSS.n1862 0.0816765
R4517 VSS.n1847 VSS.n1836 0.0816765
R4518 VSS.n1278 VSS.n707 0.0816765
R4519 VSS.n1269 VSS.n716 0.0816765
R4520 VSS.n1194 VSS.n1193 0.0775855
R4521 VSS.n866 VSS.n865 0.0775245
R4522 VSS.n1871 VSS.n1870 0.0775245
R4523 VSS.n744 VSS.n742 0.0775245
R4524 VSS.n867 VSS.n810 0.0772485
R4525 VSS.n1872 VSS.n63 0.0772485
R4526 VSS.n741 VSS.n740 0.0772485
R4527 VSS.n1287 VSS 0.075875
R4528 VSS.n1210 VSS.n1209 0.0691842
R4529 VSS.n1223 VSS.n759 0.0691842
R4530 VSS.n848 VSS.n685 0.0636458
R4531 VSS.n1749 VSS.n1738 0.0627478
R4532 VSS.n241 VSS.n109 0.0627478
R4533 VSS.n472 VSS.n471 0.0627242
R4534 VSS.n1445 VSS.n1444 0.0627242
R4535 VSS.n943 VSS.n928 0.0627242
R4536 VSS.n1552 VSS.n616 0.0627242
R4537 VSS.n708 VSS.n686 0.0603544
R4538 VSS.n1070 VSS.n1065 0.0592697
R4539 VSS.n1076 VSS.n1074 0.0592697
R4540 VSS.n841 VSS.n840 0.0579872
R4541 VSS.n874 VSS.n804 0.0579872
R4542 VSS.n1862 VSS.n1861 0.0579872
R4543 VSS.n1847 VSS.n1846 0.0579872
R4544 VSS.n1278 VSS.n706 0.0579872
R4545 VSS.n716 VSS.n715 0.0579872
R4546 VSS.n1353 VSS.n1297 0.057534
R4547 VSS.n1041 VSS.n891 0.057534
R4548 VSS.n670 VSS.n669 0.057534
R4549 VSS.n833 VSS.n828 0.0554296
R4550 VSS.n826 VSS.n796 0.0554296
R4551 VSS.n1854 VSS.n80 0.0554296
R4552 VSS.n699 VSS.n698 0.0554296
R4553 VSS.n846 VSS.n810 0.0524018
R4554 VSS.n1254 VSS.n63 0.0524018
R4555 VSS.n740 VSS.n739 0.0524018
R4556 VSS.n582 VSS.n581 0.049628
R4557 VSS.n1839 VSS.n1838 0.0437524
R4558 VSS.n855 VSS.n854 0.0385982
R4559 VSS.n1250 VSS.n1249 0.0385982
R4560 VSS.n736 VSS.n55 0.0385982
R4561 VSS.n821 VSS.n812 0.0372991
R4562 VSS.n1869 VSS.n68 0.0372991
R4563 VSS.n743 VSS.n727 0.0372991
R4564 VSS.n1173 VSS.n1172 0.0336579
R4565 VSS.n1178 VSS.n1177 0.0336579
R4566 VSS VSS.n54 0.0228469
R4567 VSS.n323 VSS.n156 0.01445
R4568 VSS.n319 VSS.n156 0.01445
R4569 VSS.n319 VSS.n318 0.01445
R4570 VSS.n318 VSS.n317 0.01445
R4571 VSS.n317 VSS.n158 0.01445
R4572 VSS.n313 VSS.n158 0.01445
R4573 VSS.n313 VSS.n312 0.01445
R4574 VSS.n312 VSS.n311 0.01445
R4575 VSS.n311 VSS.n160 0.01445
R4576 VSS.n307 VSS.n160 0.01445
R4577 VSS.n307 VSS.n306 0.01445
R4578 VSS.n306 VSS.n162 0.01445
R4579 VSS.n302 VSS.n162 0.01445
R4580 VSS.n302 VSS.n301 0.01445
R4581 VSS.n301 VSS.n300 0.01445
R4582 VSS.n300 VSS.n164 0.01445
R4583 VSS.n296 VSS.n164 0.01445
R4584 VSS.n296 VSS.n295 0.01445
R4585 VSS.n295 VSS.n294 0.01445
R4586 VSS.n294 VSS.n166 0.01445
R4587 VSS.n289 VSS.n166 0.01445
R4588 VSS.n289 VSS.n288 0.01445
R4589 VSS.n288 VSS.n287 0.01445
R4590 VSS.n287 VSS.n169 0.01445
R4591 VSS.n283 VSS.n169 0.01445
R4592 VSS.n283 VSS.n282 0.01445
R4593 VSS.n282 VSS.n281 0.01445
R4594 VSS.n281 VSS.n171 0.01445
R4595 VSS.n204 VSS.n171 0.01445
R4596 VSS.n205 VSS.n204 0.01445
R4597 VSS.n206 VSS.n205 0.01445
R4598 VSS.n206 VSS.n202 0.01445
R4599 VSS.n210 VSS.n202 0.01445
R4600 VSS.n211 VSS.n210 0.01445
R4601 VSS.n212 VSS.n200 0.01445
R4602 VSS.n217 VSS.n200 0.01445
R4603 VSS.n218 VSS.n217 0.01445
R4604 VSS.n219 VSS.n218 0.01445
R4605 VSS.n219 VSS.n198 0.01445
R4606 VSS.n223 VSS.n198 0.01445
R4607 VSS.n224 VSS.n223 0.01445
R4608 VSS.n225 VSS.n224 0.01445
R4609 VSS.n225 VSS.n196 0.01445
R4610 VSS.n229 VSS.n196 0.01445
R4611 VSS.n230 VSS.n229 0.01445
R4612 VSS.n268 VSS.n230 0.01445
R4613 VSS.n268 VSS.n267 0.01445
R4614 VSS.n267 VSS.n266 0.01445
R4615 VSS.n266 VSS.n231 0.01445
R4616 VSS.n262 VSS.n231 0.01445
R4617 VSS.n262 VSS.n261 0.01445
R4618 VSS.n261 VSS.n260 0.01445
R4619 VSS.n260 VSS.n233 0.01445
R4620 VSS.n256 VSS.n233 0.01445
R4621 VSS.n256 VSS.n255 0.01445
R4622 VSS.n255 VSS.n237 0.01445
R4623 VSS.n251 VSS.n237 0.01445
R4624 VSS.n251 VSS.n250 0.01445
R4625 VSS.n250 VSS.n249 0.01445
R4626 VSS.n249 VSS.n239 0.01445
R4627 VSS.n245 VSS.n239 0.01445
R4628 VSS.n245 VSS.n244 0.01445
R4629 VSS.n244 VSS.n243 0.01445
R4630 VSS.n1650 VSS.n327 0.01445
R4631 VSS.n1646 VSS.n327 0.01445
R4632 VSS.n1646 VSS.n1645 0.01445
R4633 VSS.n1645 VSS.n1644 0.01445
R4634 VSS.n1644 VSS.n329 0.01445
R4635 VSS.n1640 VSS.n329 0.01445
R4636 VSS.n1640 VSS.n1639 0.01445
R4637 VSS.n1639 VSS.n1638 0.01445
R4638 VSS.n1638 VSS.n331 0.01445
R4639 VSS.n1634 VSS.n331 0.01445
R4640 VSS.n1634 VSS.n1633 0.01445
R4641 VSS.n1633 VSS.n333 0.01445
R4642 VSS.n1629 VSS.n333 0.01445
R4643 VSS.n1629 VSS.n1628 0.01445
R4644 VSS.n1628 VSS.n1627 0.01445
R4645 VSS.n1627 VSS.n335 0.01445
R4646 VSS.n1623 VSS.n335 0.01445
R4647 VSS.n1623 VSS.n1622 0.01445
R4648 VSS.n1622 VSS.n1621 0.01445
R4649 VSS.n1621 VSS.n337 0.01445
R4650 VSS.n1616 VSS.n337 0.01445
R4651 VSS.n1616 VSS.n1615 0.01445
R4652 VSS.n1615 VSS.n1614 0.01445
R4653 VSS.n1614 VSS.n340 0.01445
R4654 VSS.n1610 VSS.n340 0.01445
R4655 VSS.n1610 VSS.n1609 0.01445
R4656 VSS.n1609 VSS.n1608 0.01445
R4657 VSS.n1608 VSS.n342 0.01445
R4658 VSS.n369 VSS.n342 0.01445
R4659 VSS.n370 VSS.n369 0.01445
R4660 VSS.n371 VSS.n370 0.01445
R4661 VSS.n371 VSS.n367 0.01445
R4662 VSS.n375 VSS.n367 0.01445
R4663 VSS.n376 VSS.n375 0.01445
R4664 VSS.n377 VSS.n365 0.01445
R4665 VSS.n382 VSS.n365 0.01445
R4666 VSS.n383 VSS.n382 0.01445
R4667 VSS.n384 VSS.n383 0.01445
R4668 VSS.n384 VSS.n363 0.01445
R4669 VSS.n388 VSS.n363 0.01445
R4670 VSS.n389 VSS.n388 0.01445
R4671 VSS.n390 VSS.n389 0.01445
R4672 VSS.n390 VSS.n361 0.01445
R4673 VSS.n394 VSS.n361 0.01445
R4674 VSS.n395 VSS.n394 0.01445
R4675 VSS.n1595 VSS.n395 0.01445
R4676 VSS.n1595 VSS.n1594 0.01445
R4677 VSS.n1594 VSS.n1593 0.01445
R4678 VSS.n1593 VSS.n396 0.01445
R4679 VSS.n1589 VSS.n396 0.01445
R4680 VSS.n1589 VSS.n1588 0.01445
R4681 VSS.n1588 VSS.n1587 0.01445
R4682 VSS.n1587 VSS.n398 0.01445
R4683 VSS.n1583 VSS.n398 0.01445
R4684 VSS.n1583 VSS.n1582 0.01445
R4685 VSS.n1582 VSS.n400 0.01445
R4686 VSS.n1578 VSS.n400 0.01445
R4687 VSS.n1578 VSS.n1577 0.01445
R4688 VSS.n1577 VSS.n1576 0.01445
R4689 VSS.n1576 VSS.n402 0.01445
R4690 VSS.n1572 VSS.n402 0.01445
R4691 VSS.n1572 VSS.n1571 0.01445
R4692 VSS.n1571 VSS.n1570 0.01445
R4693 VSS.n1570 VSS.n404 0.01445
R4694 VSS.n579 VSS.n404 0.01445
R4695 VSS.n580 VSS.n579 0.01445
R4696 VSS.n1655 VSS.n1654 0.01445
R4697 VSS.n1655 VSS.n153 0.01445
R4698 VSS.n1659 VSS.n153 0.01445
R4699 VSS.n1660 VSS.n1659 0.01445
R4700 VSS.n1661 VSS.n1660 0.01445
R4701 VSS.n1661 VSS.n151 0.01445
R4702 VSS.n1665 VSS.n151 0.01445
R4703 VSS.n1666 VSS.n1665 0.01445
R4704 VSS.n1667 VSS.n1666 0.01445
R4705 VSS.n1667 VSS.n149 0.01445
R4706 VSS.n1672 VSS.n149 0.01445
R4707 VSS.n1673 VSS.n1672 0.01445
R4708 VSS.n1674 VSS.n1673 0.01445
R4709 VSS.n1674 VSS.n147 0.01445
R4710 VSS.n1678 VSS.n147 0.01445
R4711 VSS.n1679 VSS.n1678 0.01445
R4712 VSS.n1680 VSS.n1679 0.01445
R4713 VSS.n1680 VSS.n145 0.01445
R4714 VSS.n1684 VSS.n145 0.01445
R4715 VSS.n1685 VSS.n1684 0.01445
R4716 VSS.n1688 VSS.n1685 0.01445
R4717 VSS.n1689 VSS.n1688 0.01445
R4718 VSS.n1690 VSS.n1689 0.01445
R4719 VSS.n1690 VSS.n143 0.01445
R4720 VSS.n1694 VSS.n143 0.01445
R4721 VSS.n1695 VSS.n1694 0.01445
R4722 VSS.n1696 VSS.n1695 0.01445
R4723 VSS.n1696 VSS.n141 0.01445
R4724 VSS.n1702 VSS.n141 0.01445
R4725 VSS.n1703 VSS.n1702 0.01445
R4726 VSS.n1704 VSS.n1703 0.01445
R4727 VSS.n1704 VSS.n139 0.01445
R4728 VSS.n1708 VSS.n139 0.01445
R4729 VSS.n1709 VSS.n1708 0.01445
R4730 VSS.n1710 VSS.n137 0.01445
R4731 VSS.n1716 VSS.n137 0.01445
R4732 VSS.n1717 VSS.n1716 0.01445
R4733 VSS.n1718 VSS.n1717 0.01445
R4734 VSS.n1718 VSS.n135 0.01445
R4735 VSS.n1722 VSS.n135 0.01445
R4736 VSS.n1723 VSS.n1722 0.01445
R4737 VSS.n1724 VSS.n1723 0.01445
R4738 VSS.n1724 VSS.n133 0.01445
R4739 VSS.n1728 VSS.n133 0.01445
R4740 VSS.n1729 VSS.n1728 0.01445
R4741 VSS.n1776 VSS.n1729 0.01445
R4742 VSS.n1776 VSS.n1775 0.01445
R4743 VSS.n1775 VSS.n1774 0.01445
R4744 VSS.n1774 VSS.n1730 0.01445
R4745 VSS.n1770 VSS.n1730 0.01445
R4746 VSS.n1770 VSS.n1769 0.01445
R4747 VSS.n1769 VSS.n1768 0.01445
R4748 VSS.n1768 VSS.n1732 0.01445
R4749 VSS.n1764 VSS.n1732 0.01445
R4750 VSS.n1764 VSS.n1763 0.01445
R4751 VSS.n1763 VSS.n1734 0.01445
R4752 VSS.n1759 VSS.n1734 0.01445
R4753 VSS.n1759 VSS.n1758 0.01445
R4754 VSS.n1758 VSS.n1757 0.01445
R4755 VSS.n1757 VSS.n1736 0.01445
R4756 VSS.n1753 VSS.n1736 0.01445
R4757 VSS.n1753 VSS.n1752 0.01445
R4758 VSS.n1752 VSS.n1751 0.01445
R4759 VSS.n1656 VSS.n154 0.01445
R4760 VSS.n1657 VSS.n1656 0.01445
R4761 VSS.n1658 VSS.n1657 0.01445
R4762 VSS.n1658 VSS.n152 0.01445
R4763 VSS.n1662 VSS.n152 0.01445
R4764 VSS.n1663 VSS.n1662 0.01445
R4765 VSS.n1664 VSS.n1663 0.01445
R4766 VSS.n1664 VSS.n150 0.01445
R4767 VSS.n1668 VSS.n150 0.01445
R4768 VSS.n1669 VSS.n1668 0.01445
R4769 VSS.n1671 VSS.n148 0.01445
R4770 VSS.n1675 VSS.n148 0.01445
R4771 VSS.n1676 VSS.n1675 0.01445
R4772 VSS.n1677 VSS.n1676 0.01445
R4773 VSS.n1677 VSS.n146 0.01445
R4774 VSS.n1681 VSS.n146 0.01445
R4775 VSS.n1682 VSS.n1681 0.01445
R4776 VSS.n1683 VSS.n1682 0.01445
R4777 VSS.n1687 VSS.n1686 0.01445
R4778 VSS.n1687 VSS.n144 0.01445
R4779 VSS.n1691 VSS.n144 0.01445
R4780 VSS.n1692 VSS.n1691 0.01445
R4781 VSS.n1693 VSS.n1692 0.01445
R4782 VSS.n1693 VSS.n142 0.01445
R4783 VSS.n1697 VSS.n142 0.01445
R4784 VSS.n1698 VSS.n1697 0.01445
R4785 VSS.n1701 VSS.n140 0.01445
R4786 VSS.n1705 VSS.n140 0.01445
R4787 VSS.n1706 VSS.n1705 0.01445
R4788 VSS.n1707 VSS.n1706 0.01445
R4789 VSS.n1707 VSS.n138 0.01445
R4790 VSS.n1711 VSS.n138 0.01445
R4791 VSS.n1712 VSS.n1711 0.01445
R4792 VSS.n1715 VSS.n1712 0.01445
R4793 VSS.n1719 VSS.n136 0.01445
R4794 VSS.n1720 VSS.n1719 0.01445
R4795 VSS.n1721 VSS.n1720 0.01445
R4796 VSS.n1721 VSS.n134 0.01445
R4797 VSS.n1725 VSS.n134 0.01445
R4798 VSS.n1726 VSS.n1725 0.01445
R4799 VSS.n1727 VSS.n1726 0.01445
R4800 VSS.n1727 VSS.n131 0.01445
R4801 VSS.n1777 VSS.n132 0.01445
R4802 VSS.n1773 VSS.n132 0.01445
R4803 VSS.n1773 VSS.n1772 0.01445
R4804 VSS.n1772 VSS.n1771 0.01445
R4805 VSS.n1771 VSS.n1731 0.01445
R4806 VSS.n1767 VSS.n1731 0.01445
R4807 VSS.n1767 VSS.n1766 0.01445
R4808 VSS.n1766 VSS.n1765 0.01445
R4809 VSS.n1762 VSS.n1761 0.01445
R4810 VSS.n1761 VSS.n1760 0.01445
R4811 VSS.n1760 VSS.n1735 0.01445
R4812 VSS.n1756 VSS.n1735 0.01445
R4813 VSS.n1756 VSS.n1755 0.01445
R4814 VSS.n1755 VSS.n1754 0.01445
R4815 VSS.n1754 VSS.n1737 0.01445
R4816 VSS.n1750 VSS.n1737 0.01445
R4817 VSS.n467 VSS.n456 0.01445
R4818 VSS.n467 VSS.n466 0.01445
R4819 VSS.n466 VSS.n465 0.01445
R4820 VSS.n465 VSS.n458 0.01445
R4821 VSS.n461 VSS.n458 0.01445
R4822 VSS.n461 VSS.n460 0.01445
R4823 VSS.n460 VSS.n451 0.01445
R4824 VSS.n482 VSS.n451 0.01445
R4825 VSS.n483 VSS.n482 0.01445
R4826 VSS.n484 VSS.n483 0.01445
R4827 VSS.n484 VSS.n449 0.01445
R4828 VSS.n488 VSS.n449 0.01445
R4829 VSS.n489 VSS.n488 0.01445
R4830 VSS.n490 VSS.n489 0.01445
R4831 VSS.n490 VSS.n447 0.01445
R4832 VSS.n494 VSS.n447 0.01445
R4833 VSS.n495 VSS.n494 0.01445
R4834 VSS.n544 VSS.n495 0.01445
R4835 VSS.n544 VSS.n543 0.01445
R4836 VSS.n543 VSS.n542 0.01445
R4837 VSS.n542 VSS.n496 0.01445
R4838 VSS.n538 VSS.n496 0.01445
R4839 VSS.n538 VSS.n537 0.01445
R4840 VSS.n537 VSS.n536 0.01445
R4841 VSS.n536 VSS.n498 0.01445
R4842 VSS.n532 VSS.n498 0.01445
R4843 VSS.n532 VSS.n531 0.01445
R4844 VSS.n531 VSS.n499 0.01445
R4845 VSS.n527 VSS.n499 0.01445
R4846 VSS.n526 VSS.n525 0.01445
R4847 VSS.n525 VSS.n501 0.01445
R4848 VSS.n521 VSS.n501 0.01445
R4849 VSS.n521 VSS.n520 0.01445
R4850 VSS.n520 VSS.n519 0.01445
R4851 VSS.n519 VSS.n503 0.01445
R4852 VSS.n514 VSS.n503 0.01445
R4853 VSS.n514 VSS.n513 0.01445
R4854 VSS.n513 VSS.n512 0.01445
R4855 VSS.n512 VSS.n505 0.01445
R4856 VSS.n508 VSS.n505 0.01445
R4857 VSS.n508 VSS.n507 0.01445
R4858 VSS.n507 VSS.n437 0.01445
R4859 VSS.n559 VSS.n437 0.01445
R4860 VSS.n560 VSS.n559 0.01445
R4861 VSS.n561 VSS.n560 0.01445
R4862 VSS.n561 VSS.n435 0.01445
R4863 VSS.n565 VSS.n435 0.01445
R4864 VSS.n566 VSS.n565 0.01445
R4865 VSS.n567 VSS.n566 0.01445
R4866 VSS.n567 VSS.n433 0.01445
R4867 VSS.n571 VSS.n433 0.01445
R4868 VSS.n572 VSS.n571 0.01445
R4869 VSS.n599 VSS.n572 0.01445
R4870 VSS.n599 VSS.n598 0.01445
R4871 VSS.n598 VSS.n597 0.01445
R4872 VSS.n597 VSS.n573 0.01445
R4873 VSS.n593 VSS.n573 0.01445
R4874 VSS.n593 VSS.n592 0.01445
R4875 VSS.n592 VSS.n591 0.01445
R4876 VSS.n591 VSS.n575 0.01445
R4877 VSS.n587 VSS.n575 0.01445
R4878 VSS.n587 VSS.n586 0.01445
R4879 VSS.n586 VSS.n585 0.01445
R4880 VSS.n469 VSS.n468 0.01445
R4881 VSS.n468 VSS.n457 0.01445
R4882 VSS.n464 VSS.n457 0.01445
R4883 VSS.n464 VSS.n463 0.01445
R4884 VSS.n463 VSS.n462 0.01445
R4885 VSS.n462 VSS.n459 0.01445
R4886 VSS.n459 VSS.n452 0.01445
R4887 VSS.n481 VSS.n452 0.01445
R4888 VSS.n485 VSS.n450 0.01445
R4889 VSS.n486 VSS.n485 0.01445
R4890 VSS.n487 VSS.n486 0.01445
R4891 VSS.n487 VSS.n448 0.01445
R4892 VSS.n491 VSS.n448 0.01445
R4893 VSS.n492 VSS.n491 0.01445
R4894 VSS.n493 VSS.n492 0.01445
R4895 VSS.n493 VSS.n445 0.01445
R4896 VSS.n545 VSS.n446 0.01445
R4897 VSS.n541 VSS.n446 0.01445
R4898 VSS.n541 VSS.n540 0.01445
R4899 VSS.n540 VSS.n539 0.01445
R4900 VSS.n539 VSS.n497 0.01445
R4901 VSS.n535 VSS.n497 0.01445
R4902 VSS.n535 VSS.n534 0.01445
R4903 VSS.n534 VSS.n533 0.01445
R4904 VSS.n530 VSS.n529 0.01445
R4905 VSS.n529 VSS.n528 0.01445
R4906 VSS.n528 VSS.n500 0.01445
R4907 VSS.n524 VSS.n500 0.01445
R4908 VSS.n524 VSS.n523 0.01445
R4909 VSS.n523 VSS.n522 0.01445
R4910 VSS.n522 VSS.n502 0.01445
R4911 VSS.n518 VSS.n502 0.01445
R4912 VSS.n516 VSS.n515 0.01445
R4913 VSS.n515 VSS.n504 0.01445
R4914 VSS.n511 VSS.n504 0.01445
R4915 VSS.n511 VSS.n510 0.01445
R4916 VSS.n510 VSS.n509 0.01445
R4917 VSS.n509 VSS.n506 0.01445
R4918 VSS.n506 VSS.n438 0.01445
R4919 VSS.n558 VSS.n438 0.01445
R4920 VSS.n562 VSS.n436 0.01445
R4921 VSS.n563 VSS.n562 0.01445
R4922 VSS.n564 VSS.n563 0.01445
R4923 VSS.n564 VSS.n434 0.01445
R4924 VSS.n568 VSS.n434 0.01445
R4925 VSS.n569 VSS.n568 0.01445
R4926 VSS.n570 VSS.n569 0.01445
R4927 VSS.n570 VSS.n431 0.01445
R4928 VSS.n600 VSS.n432 0.01445
R4929 VSS.n596 VSS.n432 0.01445
R4930 VSS.n596 VSS.n595 0.01445
R4931 VSS.n595 VSS.n594 0.01445
R4932 VSS.n594 VSS.n574 0.01445
R4933 VSS.n590 VSS.n574 0.01445
R4934 VSS.n590 VSS.n589 0.01445
R4935 VSS.n589 VSS.n588 0.01445
R4936 VSS.n588 VSS.n576 0.01445
R4937 VSS.n584 VSS.n576 0.01445
R4938 VSS.n1649 VSS.n1648 0.01445
R4939 VSS.n1648 VSS.n1647 0.01445
R4940 VSS.n1647 VSS.n328 0.01445
R4941 VSS.n1643 VSS.n328 0.01445
R4942 VSS.n1643 VSS.n1642 0.01445
R4943 VSS.n1642 VSS.n1641 0.01445
R4944 VSS.n1641 VSS.n330 0.01445
R4945 VSS.n1637 VSS.n330 0.01445
R4946 VSS.n1637 VSS.n1636 0.01445
R4947 VSS.n1636 VSS.n1635 0.01445
R4948 VSS.n1632 VSS.n1631 0.01445
R4949 VSS.n1631 VSS.n1630 0.01445
R4950 VSS.n1630 VSS.n334 0.01445
R4951 VSS.n1626 VSS.n334 0.01445
R4952 VSS.n1626 VSS.n1625 0.01445
R4953 VSS.n1625 VSS.n1624 0.01445
R4954 VSS.n1624 VSS.n336 0.01445
R4955 VSS.n1620 VSS.n336 0.01445
R4956 VSS.n1618 VSS.n1617 0.01445
R4957 VSS.n1617 VSS.n339 0.01445
R4958 VSS.n1613 VSS.n339 0.01445
R4959 VSS.n1613 VSS.n1612 0.01445
R4960 VSS.n1612 VSS.n1611 0.01445
R4961 VSS.n1611 VSS.n341 0.01445
R4962 VSS.n1607 VSS.n341 0.01445
R4963 VSS.n1607 VSS.n1606 0.01445
R4964 VSS.n368 VSS.n343 0.01445
R4965 VSS.n372 VSS.n368 0.01445
R4966 VSS.n373 VSS.n372 0.01445
R4967 VSS.n374 VSS.n373 0.01445
R4968 VSS.n374 VSS.n366 0.01445
R4969 VSS.n378 VSS.n366 0.01445
R4970 VSS.n379 VSS.n378 0.01445
R4971 VSS.n381 VSS.n379 0.01445
R4972 VSS.n385 VSS.n364 0.01445
R4973 VSS.n386 VSS.n385 0.01445
R4974 VSS.n387 VSS.n386 0.01445
R4975 VSS.n387 VSS.n362 0.01445
R4976 VSS.n391 VSS.n362 0.01445
R4977 VSS.n392 VSS.n391 0.01445
R4978 VSS.n393 VSS.n392 0.01445
R4979 VSS.n393 VSS.n359 0.01445
R4980 VSS.n1596 VSS.n360 0.01445
R4981 VSS.n1592 VSS.n360 0.01445
R4982 VSS.n1592 VSS.n1591 0.01445
R4983 VSS.n1591 VSS.n1590 0.01445
R4984 VSS.n1590 VSS.n397 0.01445
R4985 VSS.n1586 VSS.n397 0.01445
R4986 VSS.n1586 VSS.n1585 0.01445
R4987 VSS.n1585 VSS.n1584 0.01445
R4988 VSS.n1581 VSS.n1580 0.01445
R4989 VSS.n1580 VSS.n1579 0.01445
R4990 VSS.n1579 VSS.n401 0.01445
R4991 VSS.n1575 VSS.n401 0.01445
R4992 VSS.n1575 VSS.n1574 0.01445
R4993 VSS.n1574 VSS.n1573 0.01445
R4994 VSS.n1573 VSS.n403 0.01445
R4995 VSS.n1569 VSS.n403 0.01445
R4996 VSS.n578 VSS.n405 0.01445
R4997 VSS.n578 VSS.n577 0.01445
R4998 VSS.n1441 VSS.n1311 0.01445
R4999 VSS.n1441 VSS.n1440 0.01445
R5000 VSS.n1440 VSS.n1439 0.01445
R5001 VSS.n1439 VSS.n1313 0.01445
R5002 VSS.n1435 VSS.n1313 0.01445
R5003 VSS.n1435 VSS.n1434 0.01445
R5004 VSS.n1434 VSS.n1433 0.01445
R5005 VSS.n1433 VSS.n1315 0.01445
R5006 VSS.n1428 VSS.n1315 0.01445
R5007 VSS.n1428 VSS.n1427 0.01445
R5008 VSS.n1427 VSS.n1426 0.01445
R5009 VSS.n1426 VSS.n1318 0.01445
R5010 VSS.n1422 VSS.n1318 0.01445
R5011 VSS.n1422 VSS.n1421 0.01445
R5012 VSS.n1421 VSS.n1420 0.01445
R5013 VSS.n1420 VSS.n1320 0.01445
R5014 VSS.n1416 VSS.n1320 0.01445
R5015 VSS.n1416 VSS.n1415 0.01445
R5016 VSS.n1415 VSS.n1322 0.01445
R5017 VSS.n1411 VSS.n1322 0.01445
R5018 VSS.n1411 VSS.n1410 0.01445
R5019 VSS.n1410 VSS.n1409 0.01445
R5020 VSS.n1409 VSS.n1324 0.01445
R5021 VSS.n1405 VSS.n1324 0.01445
R5022 VSS.n1405 VSS.n1404 0.01445
R5023 VSS.n1404 VSS.n1403 0.01445
R5024 VSS.n1403 VSS.n1326 0.01445
R5025 VSS.n1398 VSS.n1326 0.01445
R5026 VSS.n1398 VSS.n1397 0.01445
R5027 VSS.n1396 VSS.n1329 0.01445
R5028 VSS.n1392 VSS.n1329 0.01445
R5029 VSS.n1392 VSS.n1391 0.01445
R5030 VSS.n1391 VSS.n1390 0.01445
R5031 VSS.n1390 VSS.n1331 0.01445
R5032 VSS.n1380 VSS.n1331 0.01445
R5033 VSS.n1380 VSS.n1379 0.01445
R5034 VSS.n1379 VSS.n1378 0.01445
R5035 VSS.n1378 VSS.n1333 0.01445
R5036 VSS.n1374 VSS.n1333 0.01445
R5037 VSS.n1374 VSS.n1373 0.01445
R5038 VSS.n1373 VSS.n1372 0.01445
R5039 VSS.n1372 VSS.n1335 0.01445
R5040 VSS.n1368 VSS.n1335 0.01445
R5041 VSS.n1368 VSS.n1367 0.01445
R5042 VSS.n1367 VSS.n1349 0.01445
R5043 VSS.n1363 VSS.n1349 0.01445
R5044 VSS.n1363 VSS.n1362 0.01445
R5045 VSS.n1362 VSS.n1361 0.01445
R5046 VSS.n1361 VSS.n1351 0.01445
R5047 VSS.n1357 VSS.n1351 0.01445
R5048 VSS.n1357 VSS.n1356 0.01445
R5049 VSS.n1356 VSS.n1355 0.01445
R5050 VSS.n1443 VSS.n1442 0.01445
R5051 VSS.n1442 VSS.n1312 0.01445
R5052 VSS.n1438 VSS.n1312 0.01445
R5053 VSS.n1438 VSS.n1437 0.01445
R5054 VSS.n1437 VSS.n1436 0.01445
R5055 VSS.n1436 VSS.n1314 0.01445
R5056 VSS.n1432 VSS.n1314 0.01445
R5057 VSS.n1432 VSS.n1431 0.01445
R5058 VSS.n1429 VSS.n1317 0.01445
R5059 VSS.n1425 VSS.n1317 0.01445
R5060 VSS.n1425 VSS.n1424 0.01445
R5061 VSS.n1424 VSS.n1423 0.01445
R5062 VSS.n1423 VSS.n1319 0.01445
R5063 VSS.n1419 VSS.n1319 0.01445
R5064 VSS.n1419 VSS.n1418 0.01445
R5065 VSS.n1418 VSS.n1417 0.01445
R5066 VSS.n1414 VSS.n1413 0.01445
R5067 VSS.n1413 VSS.n1412 0.01445
R5068 VSS.n1412 VSS.n1323 0.01445
R5069 VSS.n1408 VSS.n1323 0.01445
R5070 VSS.n1408 VSS.n1407 0.01445
R5071 VSS.n1407 VSS.n1406 0.01445
R5072 VSS.n1406 VSS.n1325 0.01445
R5073 VSS.n1402 VSS.n1325 0.01445
R5074 VSS.n1400 VSS.n1399 0.01445
R5075 VSS.n1399 VSS.n1328 0.01445
R5076 VSS.n1395 VSS.n1328 0.01445
R5077 VSS.n1395 VSS.n1394 0.01445
R5078 VSS.n1394 VSS.n1393 0.01445
R5079 VSS.n1393 VSS.n1330 0.01445
R5080 VSS.n1389 VSS.n1330 0.01445
R5081 VSS.n1389 VSS.n1388 0.01445
R5082 VSS.n1381 VSS.n1332 0.01445
R5083 VSS.n1377 VSS.n1332 0.01445
R5084 VSS.n1377 VSS.n1376 0.01445
R5085 VSS.n1376 VSS.n1375 0.01445
R5086 VSS.n1375 VSS.n1334 0.01445
R5087 VSS.n1371 VSS.n1334 0.01445
R5088 VSS.n1371 VSS.n1370 0.01445
R5089 VSS.n1370 VSS.n1369 0.01445
R5090 VSS.n1366 VSS.n1365 0.01445
R5091 VSS.n1365 VSS.n1364 0.01445
R5092 VSS.n1364 VSS.n1350 0.01445
R5093 VSS.n1360 VSS.n1350 0.01445
R5094 VSS.n1360 VSS.n1359 0.01445
R5095 VSS.n1359 VSS.n1358 0.01445
R5096 VSS.n1358 VSS.n1352 0.01445
R5097 VSS.n1354 VSS.n1352 0.01445
R5098 VSS.n941 VSS.n940 0.01445
R5099 VSS.n940 VSS.n939 0.01445
R5100 VSS.n939 VSS.n930 0.01445
R5101 VSS.n935 VSS.n930 0.01445
R5102 VSS.n935 VSS.n934 0.01445
R5103 VSS.n934 VSS.n933 0.01445
R5104 VSS.n933 VSS.n920 0.01445
R5105 VSS.n952 VSS.n920 0.01445
R5106 VSS.n953 VSS.n952 0.01445
R5107 VSS.n954 VSS.n953 0.01445
R5108 VSS.n954 VSS.n918 0.01445
R5109 VSS.n958 VSS.n918 0.01445
R5110 VSS.n959 VSS.n958 0.01445
R5111 VSS.n960 VSS.n959 0.01445
R5112 VSS.n960 VSS.n916 0.01445
R5113 VSS.n964 VSS.n916 0.01445
R5114 VSS.n965 VSS.n964 0.01445
R5115 VSS.n997 VSS.n965 0.01445
R5116 VSS.n997 VSS.n996 0.01445
R5117 VSS.n996 VSS.n995 0.01445
R5118 VSS.n995 VSS.n966 0.01445
R5119 VSS.n991 VSS.n966 0.01445
R5120 VSS.n991 VSS.n990 0.01445
R5121 VSS.n990 VSS.n989 0.01445
R5122 VSS.n989 VSS.n968 0.01445
R5123 VSS.n985 VSS.n968 0.01445
R5124 VSS.n985 VSS.n984 0.01445
R5125 VSS.n984 VSS.n969 0.01445
R5126 VSS.n980 VSS.n969 0.01445
R5127 VSS.n979 VSS.n978 0.01445
R5128 VSS.n978 VSS.n971 0.01445
R5129 VSS.n974 VSS.n971 0.01445
R5130 VSS.n974 VSS.n973 0.01445
R5131 VSS.n973 VSS.n903 0.01445
R5132 VSS.n1014 VSS.n903 0.01445
R5133 VSS.n1015 VSS.n1014 0.01445
R5134 VSS.n1016 VSS.n1015 0.01445
R5135 VSS.n1016 VSS.n901 0.01445
R5136 VSS.n1020 VSS.n901 0.01445
R5137 VSS.n1021 VSS.n1020 0.01445
R5138 VSS.n1022 VSS.n1021 0.01445
R5139 VSS.n1022 VSS.n899 0.01445
R5140 VSS.n1026 VSS.n899 0.01445
R5141 VSS.n1027 VSS.n1026 0.01445
R5142 VSS.n1027 VSS.n897 0.01445
R5143 VSS.n1031 VSS.n897 0.01445
R5144 VSS.n1032 VSS.n1031 0.01445
R5145 VSS.n1033 VSS.n1032 0.01445
R5146 VSS.n1033 VSS.n895 0.01445
R5147 VSS.n1037 VSS.n895 0.01445
R5148 VSS.n1038 VSS.n1037 0.01445
R5149 VSS.n1039 VSS.n1038 0.01445
R5150 VSS.n942 VSS.n929 0.01445
R5151 VSS.n938 VSS.n929 0.01445
R5152 VSS.n938 VSS.n937 0.01445
R5153 VSS.n937 VSS.n936 0.01445
R5154 VSS.n936 VSS.n931 0.01445
R5155 VSS.n932 VSS.n931 0.01445
R5156 VSS.n932 VSS.n921 0.01445
R5157 VSS.n951 VSS.n921 0.01445
R5158 VSS.n955 VSS.n919 0.01445
R5159 VSS.n956 VSS.n955 0.01445
R5160 VSS.n957 VSS.n956 0.01445
R5161 VSS.n957 VSS.n917 0.01445
R5162 VSS.n961 VSS.n917 0.01445
R5163 VSS.n962 VSS.n961 0.01445
R5164 VSS.n963 VSS.n962 0.01445
R5165 VSS.n963 VSS.n914 0.01445
R5166 VSS.n998 VSS.n915 0.01445
R5167 VSS.n994 VSS.n915 0.01445
R5168 VSS.n994 VSS.n993 0.01445
R5169 VSS.n993 VSS.n992 0.01445
R5170 VSS.n992 VSS.n967 0.01445
R5171 VSS.n988 VSS.n967 0.01445
R5172 VSS.n988 VSS.n987 0.01445
R5173 VSS.n987 VSS.n986 0.01445
R5174 VSS.n983 VSS.n982 0.01445
R5175 VSS.n982 VSS.n981 0.01445
R5176 VSS.n981 VSS.n970 0.01445
R5177 VSS.n977 VSS.n970 0.01445
R5178 VSS.n977 VSS.n976 0.01445
R5179 VSS.n976 VSS.n975 0.01445
R5180 VSS.n975 VSS.n972 0.01445
R5181 VSS.n972 VSS.n904 0.01445
R5182 VSS.n1013 VSS.n902 0.01445
R5183 VSS.n1017 VSS.n902 0.01445
R5184 VSS.n1018 VSS.n1017 0.01445
R5185 VSS.n1019 VSS.n1018 0.01445
R5186 VSS.n1019 VSS.n900 0.01445
R5187 VSS.n1023 VSS.n900 0.01445
R5188 VSS.n1024 VSS.n1023 0.01445
R5189 VSS.n1025 VSS.n1024 0.01445
R5190 VSS.n1029 VSS.n1028 0.01445
R5191 VSS.n1030 VSS.n1029 0.01445
R5192 VSS.n1030 VSS.n896 0.01445
R5193 VSS.n1034 VSS.n896 0.01445
R5194 VSS.n1035 VSS.n1034 0.01445
R5195 VSS.n1036 VSS.n1035 0.01445
R5196 VSS.n1036 VSS.n894 0.01445
R5197 VSS.n1040 VSS.n894 0.01445
R5198 VSS.n1550 VSS.n1549 0.01445
R5199 VSS.n1549 VSS.n1548 0.01445
R5200 VSS.n1548 VSS.n618 0.01445
R5201 VSS.n1544 VSS.n618 0.01445
R5202 VSS.n1544 VSS.n1543 0.01445
R5203 VSS.n1543 VSS.n1542 0.01445
R5204 VSS.n1542 VSS.n620 0.01445
R5205 VSS.n1538 VSS.n620 0.01445
R5206 VSS.n1538 VSS.n1537 0.01445
R5207 VSS.n1537 VSS.n622 0.01445
R5208 VSS.n1533 VSS.n622 0.01445
R5209 VSS.n1533 VSS.n1532 0.01445
R5210 VSS.n1532 VSS.n1531 0.01445
R5211 VSS.n1531 VSS.n624 0.01445
R5212 VSS.n1527 VSS.n624 0.01445
R5213 VSS.n1527 VSS.n1526 0.01445
R5214 VSS.n1526 VSS.n1525 0.01445
R5215 VSS.n1525 VSS.n626 0.01445
R5216 VSS.n1520 VSS.n626 0.01445
R5217 VSS.n1520 VSS.n1519 0.01445
R5218 VSS.n1519 VSS.n1518 0.01445
R5219 VSS.n1518 VSS.n628 0.01445
R5220 VSS.n1514 VSS.n628 0.01445
R5221 VSS.n1514 VSS.n1513 0.01445
R5222 VSS.n1513 VSS.n1512 0.01445
R5223 VSS.n1512 VSS.n630 0.01445
R5224 VSS.n1507 VSS.n630 0.01445
R5225 VSS.n1507 VSS.n1506 0.01445
R5226 VSS.n1506 VSS.n1505 0.01445
R5227 VSS.n1502 VSS.n1501 0.01445
R5228 VSS.n1501 VSS.n1500 0.01445
R5229 VSS.n1500 VSS.n634 0.01445
R5230 VSS.n1496 VSS.n634 0.01445
R5231 VSS.n1496 VSS.n1495 0.01445
R5232 VSS.n1495 VSS.n1494 0.01445
R5233 VSS.n1494 VSS.n636 0.01445
R5234 VSS.n1490 VSS.n636 0.01445
R5235 VSS.n1490 VSS.n1489 0.01445
R5236 VSS.n1489 VSS.n1488 0.01445
R5237 VSS.n1488 VSS.n639 0.01445
R5238 VSS.n1484 VSS.n639 0.01445
R5239 VSS.n1484 VSS.n1483 0.01445
R5240 VSS.n1483 VSS.n1482 0.01445
R5241 VSS.n1482 VSS.n641 0.01445
R5242 VSS.n658 VSS.n641 0.01445
R5243 VSS.n659 VSS.n658 0.01445
R5244 VSS.n660 VSS.n659 0.01445
R5245 VSS.n660 VSS.n655 0.01445
R5246 VSS.n664 VSS.n655 0.01445
R5247 VSS.n665 VSS.n664 0.01445
R5248 VSS.n666 VSS.n665 0.01445
R5249 VSS.n666 VSS.n653 0.01445
R5250 VSS.n1551 VSS.n617 0.01445
R5251 VSS.n1547 VSS.n617 0.01445
R5252 VSS.n1547 VSS.n1546 0.01445
R5253 VSS.n1546 VSS.n1545 0.01445
R5254 VSS.n1545 VSS.n619 0.01445
R5255 VSS.n1541 VSS.n619 0.01445
R5256 VSS.n1541 VSS.n1540 0.01445
R5257 VSS.n1540 VSS.n1539 0.01445
R5258 VSS.n1536 VSS.n1535 0.01445
R5259 VSS.n1535 VSS.n1534 0.01445
R5260 VSS.n1534 VSS.n623 0.01445
R5261 VSS.n1530 VSS.n623 0.01445
R5262 VSS.n1530 VSS.n1529 0.01445
R5263 VSS.n1529 VSS.n1528 0.01445
R5264 VSS.n1528 VSS.n625 0.01445
R5265 VSS.n1524 VSS.n625 0.01445
R5266 VSS.n1522 VSS.n1521 0.01445
R5267 VSS.n1521 VSS.n627 0.01445
R5268 VSS.n1517 VSS.n627 0.01445
R5269 VSS.n1517 VSS.n1516 0.01445
R5270 VSS.n1516 VSS.n1515 0.01445
R5271 VSS.n1515 VSS.n629 0.01445
R5272 VSS.n1511 VSS.n629 0.01445
R5273 VSS.n1511 VSS.n1510 0.01445
R5274 VSS.n1508 VSS.n632 0.01445
R5275 VSS.n1504 VSS.n632 0.01445
R5276 VSS.n1504 VSS.n1503 0.01445
R5277 VSS.n1503 VSS.n633 0.01445
R5278 VSS.n1499 VSS.n633 0.01445
R5279 VSS.n1499 VSS.n1498 0.01445
R5280 VSS.n1498 VSS.n1497 0.01445
R5281 VSS.n1497 VSS.n635 0.01445
R5282 VSS.n1493 VSS.n1492 0.01445
R5283 VSS.n1492 VSS.n1491 0.01445
R5284 VSS.n1491 VSS.n638 0.01445
R5285 VSS.n1487 VSS.n638 0.01445
R5286 VSS.n1487 VSS.n1486 0.01445
R5287 VSS.n1486 VSS.n1485 0.01445
R5288 VSS.n1485 VSS.n640 0.01445
R5289 VSS.n1481 VSS.n640 0.01445
R5290 VSS.n657 VSS.n642 0.01445
R5291 VSS.n657 VSS.n656 0.01445
R5292 VSS.n661 VSS.n656 0.01445
R5293 VSS.n662 VSS.n661 0.01445
R5294 VSS.n663 VSS.n662 0.01445
R5295 VSS.n663 VSS.n654 0.01445
R5296 VSS.n667 VSS.n654 0.01445
R5297 VSS.n668 VSS.n667 0.01445
R5298 VSS.n322 VSS.n321 0.01445
R5299 VSS.n321 VSS.n320 0.01445
R5300 VSS.n320 VSS.n157 0.01445
R5301 VSS.n316 VSS.n157 0.01445
R5302 VSS.n316 VSS.n315 0.01445
R5303 VSS.n315 VSS.n314 0.01445
R5304 VSS.n314 VSS.n159 0.01445
R5305 VSS.n310 VSS.n159 0.01445
R5306 VSS.n310 VSS.n309 0.01445
R5307 VSS.n309 VSS.n308 0.01445
R5308 VSS.n305 VSS.n304 0.01445
R5309 VSS.n304 VSS.n303 0.01445
R5310 VSS.n303 VSS.n163 0.01445
R5311 VSS.n299 VSS.n163 0.01445
R5312 VSS.n299 VSS.n298 0.01445
R5313 VSS.n298 VSS.n297 0.01445
R5314 VSS.n297 VSS.n165 0.01445
R5315 VSS.n293 VSS.n165 0.01445
R5316 VSS.n291 VSS.n290 0.01445
R5317 VSS.n290 VSS.n168 0.01445
R5318 VSS.n286 VSS.n168 0.01445
R5319 VSS.n286 VSS.n285 0.01445
R5320 VSS.n285 VSS.n284 0.01445
R5321 VSS.n284 VSS.n170 0.01445
R5322 VSS.n280 VSS.n170 0.01445
R5323 VSS.n280 VSS.n279 0.01445
R5324 VSS.n203 VSS.n172 0.01445
R5325 VSS.n207 VSS.n203 0.01445
R5326 VSS.n208 VSS.n207 0.01445
R5327 VSS.n209 VSS.n208 0.01445
R5328 VSS.n209 VSS.n201 0.01445
R5329 VSS.n213 VSS.n201 0.01445
R5330 VSS.n214 VSS.n213 0.01445
R5331 VSS.n216 VSS.n214 0.01445
R5332 VSS.n220 VSS.n199 0.01445
R5333 VSS.n221 VSS.n220 0.01445
R5334 VSS.n222 VSS.n221 0.01445
R5335 VSS.n222 VSS.n197 0.01445
R5336 VSS.n226 VSS.n197 0.01445
R5337 VSS.n227 VSS.n226 0.01445
R5338 VSS.n228 VSS.n227 0.01445
R5339 VSS.n228 VSS.n194 0.01445
R5340 VSS.n269 VSS.n195 0.01445
R5341 VSS.n265 VSS.n195 0.01445
R5342 VSS.n265 VSS.n264 0.01445
R5343 VSS.n264 VSS.n263 0.01445
R5344 VSS.n263 VSS.n232 0.01445
R5345 VSS.n259 VSS.n232 0.01445
R5346 VSS.n259 VSS.n258 0.01445
R5347 VSS.n258 VSS.n257 0.01445
R5348 VSS.n254 VSS.n253 0.01445
R5349 VSS.n253 VSS.n252 0.01445
R5350 VSS.n252 VSS.n238 0.01445
R5351 VSS.n248 VSS.n238 0.01445
R5352 VSS.n248 VSS.n247 0.01445
R5353 VSS.n247 VSS.n246 0.01445
R5354 VSS.n246 VSS.n240 0.01445
R5355 VSS.n242 VSS.n240 0.01445
R5356 VSS.n1159 VSS.n778 0.0137143
R5357 VSS.n787 VSS.n786 0.0137143
R5358 VSS.n1653 VSS.n116 0.0132125
R5359 VSS.n583 VSS.n428 0.0132125
R5360 VSS.n1651 VSS.n326 0.0132125
R5361 VSS.n324 VSS.n155 0.0132125
R5362 VSS.n1671 VSS.n1670 0.0113
R5363 VSS.n1686 VSS.n122 0.0113
R5364 VSS.n1701 VSS.n1700 0.0113
R5365 VSS.n1714 VSS.n136 0.0113
R5366 VSS.n1778 VSS.n1777 0.0113
R5367 VSS.n1762 VSS.n1733 0.0113
R5368 VSS.n481 VSS.n480 0.0113
R5369 VSS.n546 VSS.n445 0.0113
R5370 VSS.n533 VSS.n442 0.0113
R5371 VSS.n518 VSS.n517 0.0113
R5372 VSS.n558 VSS.n557 0.0113
R5373 VSS.n601 VSS.n431 0.0113
R5374 VSS.n1632 VSS.n332 0.0113
R5375 VSS.n1619 VSS.n1618 0.0113
R5376 VSS.n1605 VSS.n343 0.0113
R5377 VSS.n380 VSS.n364 0.0113
R5378 VSS.n1597 VSS.n1596 0.0113
R5379 VSS.n1581 VSS.n399 0.0113
R5380 VSS.n1568 VSS.n405 0.0113
R5381 VSS.n1431 VSS.n1430 0.0113
R5382 VSS.n1417 VSS.n1321 0.0113
R5383 VSS.n1402 VSS.n1401 0.0113
R5384 VSS.n1388 VSS.n1387 0.0113
R5385 VSS.n1369 VSS.n1348 0.0113
R5386 VSS.n1354 VSS.n1353 0.0113
R5387 VSS.n951 VSS.n950 0.0113
R5388 VSS.n999 VSS.n914 0.0113
R5389 VSS.n986 VSS.n910 0.0113
R5390 VSS.n1012 VSS.n904 0.0113
R5391 VSS.n1025 VSS.n898 0.0113
R5392 VSS.n1041 VSS.n1040 0.0113
R5393 VSS.n1539 VSS.n621 0.0113
R5394 VSS.n1524 VSS.n1523 0.0113
R5395 VSS.n1510 VSS.n1509 0.0113
R5396 VSS.n637 VSS.n635 0.0113
R5397 VSS.n1481 VSS.n1480 0.0113
R5398 VSS.n669 VSS.n668 0.0113
R5399 VSS.n305 VSS.n161 0.0113
R5400 VSS.n292 VSS.n291 0.0113
R5401 VSS.n278 VSS.n172 0.0113
R5402 VSS.n215 VSS.n199 0.0113
R5403 VSS.n270 VSS.n269 0.0113
R5404 VSS.n254 VSS.n236 0.0113
R5405 VSS VSS.n790 0.0112143
R5406 VSS VSS.n1260 0.0112143
R5407 VSS.n1901 VSS.n39 0.00907409
R5408 VSS.n1901 VSS.n7 0.00907409
R5409 VSS.n46 VSS.n23 0.00805222
R5410 VSS.n1932 VSS.n1910 0.00805222
R5411 VSS.n1886 VSS.n24 0.00805222
R5412 VSS.n1931 VSS.n21 0.00805222
R5413 VSS.n1887 VSS.n25 0.00805222
R5414 VSS.n1930 VSS.n20 0.00805222
R5415 VSS.n1888 VSS.n26 0.00805222
R5416 VSS.n1929 VSS.n19 0.00805222
R5417 VSS.n1889 VSS.n27 0.00805222
R5418 VSS.n1928 VSS.n18 0.00805222
R5419 VSS.n1890 VSS.n28 0.00805222
R5420 VSS.n1927 VSS.n17 0.00805222
R5421 VSS.n1891 VSS.n29 0.00805222
R5422 VSS.n1926 VSS.n16 0.00805222
R5423 VSS.n1892 VSS.n30 0.00805222
R5424 VSS.n1925 VSS.n15 0.00805222
R5425 VSS.n1893 VSS.n31 0.00805222
R5426 VSS.n1924 VSS.n14 0.00805222
R5427 VSS.n1894 VSS.n32 0.00805222
R5428 VSS.n1923 VSS.n13 0.00805222
R5429 VSS.n1895 VSS.n33 0.00805222
R5430 VSS.n1922 VSS.n12 0.00805222
R5431 VSS.n1896 VSS.n34 0.00805222
R5432 VSS.n1921 VSS.n11 0.00805222
R5433 VSS.n1897 VSS.n35 0.00805222
R5434 VSS.n1920 VSS.n10 0.00805222
R5435 VSS.n1898 VSS.n36 0.00805222
R5436 VSS.n1919 VSS.n9 0.00805222
R5437 VSS.n1899 VSS.n37 0.00805222
R5438 VSS.n1918 VSS.n8 0.00805222
R5439 VSS.n1900 VSS.n38 0.00805222
R5440 VSS.n1917 VSS.n7 0.00805222
R5441 VSS.n1916 VSS.n6 0.00805222
R5442 VSS.n1902 VSS.n40 0.00805222
R5443 VSS.n1915 VSS.n5 0.00805222
R5444 VSS.n1903 VSS.n41 0.00805222
R5445 VSS.n1914 VSS.n4 0.00805222
R5446 VSS.n1904 VSS.n42 0.00805222
R5447 VSS.n1913 VSS.n3 0.00805222
R5448 VSS.n1905 VSS.n43 0.00805222
R5449 VSS.n1912 VSS.n2 0.00805222
R5450 VSS.n1906 VSS.n44 0.00805222
R5451 VSS.n1911 VSS.n1 0.00805222
R5452 VSS.n1936 VSS.n45 0.00805222
R5453 VSS.n46 VSS.n22 0.00805222
R5454 VSS.n1932 VSS.n23 0.00805222
R5455 VSS.n1910 VSS.n1886 0.00805222
R5456 VSS.n1931 VSS.n24 0.00805222
R5457 VSS.n1887 VSS.n21 0.00805222
R5458 VSS.n1930 VSS.n25 0.00805222
R5459 VSS.n1888 VSS.n20 0.00805222
R5460 VSS.n1929 VSS.n26 0.00805222
R5461 VSS.n1889 VSS.n19 0.00805222
R5462 VSS.n1928 VSS.n27 0.00805222
R5463 VSS.n1890 VSS.n18 0.00805222
R5464 VSS.n1927 VSS.n28 0.00805222
R5465 VSS.n1891 VSS.n17 0.00805222
R5466 VSS.n1926 VSS.n29 0.00805222
R5467 VSS.n1892 VSS.n16 0.00805222
R5468 VSS.n1925 VSS.n30 0.00805222
R5469 VSS.n1893 VSS.n15 0.00805222
R5470 VSS.n1924 VSS.n31 0.00805222
R5471 VSS.n1894 VSS.n14 0.00805222
R5472 VSS.n1923 VSS.n32 0.00805222
R5473 VSS.n1895 VSS.n13 0.00805222
R5474 VSS.n1922 VSS.n33 0.00805222
R5475 VSS.n1896 VSS.n12 0.00805222
R5476 VSS.n1921 VSS.n34 0.00805222
R5477 VSS.n1897 VSS.n11 0.00805222
R5478 VSS.n1920 VSS.n35 0.00805222
R5479 VSS.n1898 VSS.n10 0.00805222
R5480 VSS.n1919 VSS.n36 0.00805222
R5481 VSS.n1899 VSS.n9 0.00805222
R5482 VSS.n1918 VSS.n37 0.00805222
R5483 VSS.n1900 VSS.n8 0.00805222
R5484 VSS.n1917 VSS.n38 0.00805222
R5485 VSS.n1916 VSS.n39 0.00805222
R5486 VSS.n1902 VSS.n6 0.00805222
R5487 VSS.n1915 VSS.n40 0.00805222
R5488 VSS.n1903 VSS.n5 0.00805222
R5489 VSS.n1914 VSS.n41 0.00805222
R5490 VSS.n1904 VSS.n4 0.00805222
R5491 VSS.n1913 VSS.n42 0.00805222
R5492 VSS.n1905 VSS.n3 0.00805222
R5493 VSS.n1912 VSS.n43 0.00805222
R5494 VSS.n1906 VSS.n2 0.00805222
R5495 VSS.n1911 VSS.n44 0.00805222
R5496 VSS.n45 VSS.n1 0.00805222
R5497 VSS VSS.n211 0.0077
R5498 VSS VSS.n376 0.0077
R5499 VSS VSS.n1709 0.0077
R5500 VSS VSS.n526 0.0077
R5501 VSS VSS.n1396 0.0077
R5502 VSS VSS.n979 0.0077
R5503 VSS.n1502 VSS 0.0077
R5504 VSS.n212 VSS 0.00725
R5505 VSS.n377 VSS 0.00725
R5506 VSS.n1710 VSS 0.00725
R5507 VSS.n527 VSS 0.00725
R5508 VSS.n1397 VSS 0.00725
R5509 VSS.n980 VSS 0.00725
R5510 VSS.n1505 VSS 0.00725
R5511 VSS.n582 VSS.n577 0.0064625
R5512 VSS.n1094 VSS 0.004325
R5513 VSS VSS.n1286 0.004325
R5514 VSS.n1670 VSS.n1669 0.00365
R5515 VSS.n1683 VSS.n122 0.00365
R5516 VSS.n1700 VSS.n1698 0.00365
R5517 VSS.n1715 VSS.n1714 0.00365
R5518 VSS.n1778 VSS.n131 0.00365
R5519 VSS.n1765 VSS.n1733 0.00365
R5520 VSS.n1750 VSS.n1749 0.00365
R5521 VSS.n471 VSS.n469 0.00365
R5522 VSS.n480 VSS.n450 0.00365
R5523 VSS.n546 VSS.n545 0.00365
R5524 VSS.n530 VSS.n442 0.00365
R5525 VSS.n517 VSS.n516 0.00365
R5526 VSS.n557 VSS.n436 0.00365
R5527 VSS.n601 VSS.n600 0.00365
R5528 VSS.n1635 VSS.n332 0.00365
R5529 VSS.n1620 VSS.n1619 0.00365
R5530 VSS.n1606 VSS.n1605 0.00365
R5531 VSS.n381 VSS.n380 0.00365
R5532 VSS.n1597 VSS.n359 0.00365
R5533 VSS.n1584 VSS.n399 0.00365
R5534 VSS.n1569 VSS.n1568 0.00365
R5535 VSS.n1444 VSS.n1443 0.00365
R5536 VSS.n1430 VSS.n1429 0.00365
R5537 VSS.n1414 VSS.n1321 0.00365
R5538 VSS.n1401 VSS.n1400 0.00365
R5539 VSS.n1387 VSS.n1381 0.00365
R5540 VSS.n1366 VSS.n1348 0.00365
R5541 VSS.n943 VSS.n942 0.00365
R5542 VSS.n950 VSS.n919 0.00365
R5543 VSS.n999 VSS.n998 0.00365
R5544 VSS.n983 VSS.n910 0.00365
R5545 VSS.n1013 VSS.n1012 0.00365
R5546 VSS.n1028 VSS.n898 0.00365
R5547 VSS.n1552 VSS.n1551 0.00365
R5548 VSS.n1536 VSS.n621 0.00365
R5549 VSS.n1523 VSS.n1522 0.00365
R5550 VSS.n1509 VSS.n1508 0.00365
R5551 VSS.n1493 VSS.n637 0.00365
R5552 VSS.n1480 VSS.n642 0.00365
R5553 VSS.n308 VSS.n161 0.00365
R5554 VSS.n293 VSS.n292 0.00365
R5555 VSS.n279 VSS.n278 0.00365
R5556 VSS.n216 VSS.n215 0.00365
R5557 VSS.n270 VSS.n194 0.00365
R5558 VSS.n257 VSS.n236 0.00365
R5559 VSS.n242 VSS.n241 0.00365
R5560 VSS.n1907 VSS.n47 0.00236
R5561 VSS.n879 VSS.n878 0.00213148
R5562 VSS.n830 VSS.n791 0.00213148
R5563 VSS.n1909 VSS.n48 0.00192981
R5564 VSS.n1933 VSS.n48 0.00192981
R5565 VSS.n1935 VSS.n1934 0.00192981
R5566 VSS.n1909 VSS.n1908 0.00192981
R5567 VSS.n1937 VSS.n0 0.00192981
R5568 VSS.n1908 VSS.n1907 0.00192981
R5569 VSS.n1934 VSS.n1933 0.00192981
R5570 VSS.n47 VSS.n0 0.00192981
R5571 VSS.n154 VSS.n116 0.0017375
R5572 VSS.n584 VSS.n428 0.0017375
R5573 VSS.n1649 VSS.n326 0.0017375
R5574 VSS.n322 VSS.n155 0.0017375
R5575 VSS VSS.n1191 0.00168421
R5576 VSS.n1217 VSS 0.00168421
R5577 VSS.n1885 VSS 0.000925197
C0 V_out_perceptron_core a_53906_63036# 0.00168f
C1 VDD a_67218_53992# 0.09804f
C2 a_67218_55696# a_67218_53992# 0.0161f
C3 a_48931_54374# perceptron_core_0.tanh_ota_0.V_in_n 2.39106f
C4 perceptron_core_0.voltage_reference_0.v_1_25 a_44195_67876# 0.35627f
C5 a_52415_68456# VDD 0
C6 a_52415_70160# VDD 0.0475f
C7 perceptron_core_0.tanh_ota_0.V_in_p a_44195_47782# 1.99792f
C8 a_55134_51058# perceptron_core_0.voltage_reference_0.v_1_15 0.08983f
C9 perceptron_core_0.tanh_ota_0.V_ref V_w1_core 3.92601f
C10 perceptron_core_0.tanh_ota_0.V_in_n a_48233_51616# 0.17076f
C11 a_53826_51058# perceptron_core_0.voltage_reference_0.v_1_15 0.08069f
C12 perceptron_core_0.tanh_ota_0.V_in_n a_50381_62830# 0
C13 I_x2_core VDD 38.9038f
C14 perceptron_core_0.tanh_ota_0.V_in_p a_43991_51280# 2.58652f
C15 a_55134_51058# a_60034_55696# 0.15325f
C16 V_out_perceptron_core perceptron_core_0.tanh_ota_0.V_in_n 0.51062f
C17 VDD a_60034_53992# 0.07538f
C18 perceptron_core_0.tanh_ota_0.V_in_n a_44174_53200# 0.03112f
C19 perceptron_core_0.tanh_ota_0.V_in_n a_49529_59702# 0.0011f
C20 a_47887_67604# perceptron_core_0.tanh_ota_0.V_in_p 0.00479f
C21 a_44137_63442# perceptron_core_0.tanh_ota_0.V_in_p 0
C22 perceptron_core_0.gilbert_multiplier_current_1.V_x_n V_b_core 0.00705f
C23 a_44137_63442# perceptron_core_0.gilbert_multiplier_current_2.V_x_n 0
C24 a_50871_64476# perceptron_core_0.tanh_ota_0.V_in_p 0.14065f
C25 a_60043_58514# a_60034_55696# 0
C26 a_60430_60950# perceptron_core_0.voltage_reference_0.v_1_15 0.17122f
C27 a_49077_51616# a_49772_52654# 0.02724f
C28 a_47887_67604# a_44195_67876# 0
C29 a_43991_66200# V_w1_core 0.65271f
C30 a_48342_63968# perceptron_core_0.tanh_ota_0.V_in_p 0.36364f
C31 perceptron_core_0.voltage_reference_0.v_1_15 a_49772_52654# 0.30482f
C32 a_48931_54374# perceptron_core_0.voltage_reference_0.v_1_15 0
C33 a_60430_60950# a_64353_58580# 0.62866f
C34 a_49077_51616# a_48233_51616# 0.02791f
C35 a_47887_69308# VDD 0.2502f
C36 perceptron_core_0.tanh_ota_0.V_in_p a_44137_54910# 0
C37 I_x1_core V_b_core 0.87103f
C38 a_44174_64480# VDD 0.00331f
C39 a_44981_61004# perceptron_core_0.tanh_ota_0.V_in_p 0.00777f
C40 a_55134_51058# a_53906_56548# 0.0088f
C41 a_55266_65406# a_55134_65510# 0.54051f
C42 perceptron_core_0.voltage_reference_0.v_1_15 a_48233_51616# 0.03568f
C43 a_60430_60950# a_62775_58580# 0.77357f
C44 perceptron_core_0.voltage_reference_0.v_1_25 perceptron_core_0.tanh_ota_0.V_in_n 1.18253f
C45 a_52131_62540# perceptron_core_0.tanh_ota_0.V_in_p 0.12224f
C46 a_53826_51058# a_53906_56548# 0.03052f
C47 perceptron_core_0.tanh_ota_0.V_in_n V_w2_core 1.33403f
C48 a_48931_54374# V_b_core 0.72896f
C49 perceptron_core_0.tanh_ota_0.V_ref perceptron_core_0.tanh_ota_0.V_in_p 5.95733f
C50 a_55134_51058# a_55134_65510# 0.02642f
C51 perceptron_core_0.gilbert_multiplier_current_2.V_x_n perceptron_core_0.tanh_ota_0.V_ref 0.02515f
C52 a_53826_51058# a_55134_65510# 0.22359f
C53 perceptron_core_0.tanh_ota_0.V_in_n a_44195_47782# 2.37444f
C54 perceptron_core_0.tanh_ota_0.V_in_p a_43293_54910# 0.28218f
C55 perceptron_core_0.tanh_ota_0.V_ref a_44195_67876# 0.83293f
C56 I_x1_core a_43293_61004# 0.00197f
C57 a_53958_65406# a_55134_65510# 0.55712f
C58 a_48931_54374# a_49135_56824# 0.13501f
C59 a_49135_56824# a_49772_52654# 0.77508f
C60 perceptron_core_0.tanh_ota_0.V_in_n a_43991_51280# 2.16944f
C61 I_x2_core perceptron_core_0.tanh_ota_0.V_in_p 0.0817f
C62 a_55134_51058# a_53826_51058# 0.215f
C63 V_b_core a_49529_59702# 0.01286f
C64 perceptron_core_0.voltage_reference_0.v_1_15 a_60490_54844# 0.0037f
C65 a_53958_65406# a_55266_65406# 0.41277f
C66 a_49135_56824# a_48233_51616# 0
C67 a_47887_67604# perceptron_core_0.tanh_ota_0.V_in_n 0.01732f
C68 VDD a_60034_60480# 0.0951f
C69 perceptron_core_0.tanh_ota_0.V_in_p a_43991_66200# 2.72648f
C70 a_55266_50954# perceptron_core_0.tanh_ota_0.V_ref 0.28006f
C71 a_50871_64476# perceptron_core_0.tanh_ota_0.V_in_n 0.17229f
C72 perceptron_core_0.gilbert_multiplier_current_2.V_x_n a_43991_66200# 0.16229f
C73 perceptron_core_0.tanh_ota_0.V_in_p a_43293_57348# 0.00686f
C74 a_52131_62540# a_53906_63036# 0.00441f
C75 a_53958_65406# a_53826_51058# 0.70429f
C76 a_60034_55696# a_60490_54844# 0.08585f
C77 perceptron_core_0.voltage_reference_0.v_1_25 perceptron_core_0.voltage_reference_0.v_1_15 0.00769f
C78 a_44195_67876# a_43991_66200# 0.13501f
C79 a_53958_50954# perceptron_core_0.tanh_ota_0.V_ref 1.04852f
C80 a_48342_63968# perceptron_core_0.tanh_ota_0.V_in_n 0.47423f
C81 a_67218_63036# a_67218_61332# 0.0161f
C82 perceptron_core_0.voltage_reference_0.v_1_15 a_53906_54844# 0.0037f
C83 a_54068_46311# VDD 3.92843f
C84 perceptron_core_0.voltage_reference_0.v_1_25 V_b_core 0.16024f
C85 a_44981_61004# perceptron_core_0.tanh_ota_0.V_in_n 0
C86 VDD V_b 19.389f
C87 a_44174_64480# perceptron_core_0.tanh_ota_0.V_in_p 0.03585f
C88 perceptron_core_0.gilbert_multiplier_current_2.V_x_n a_44174_64480# 0.04166f
C89 a_52131_62540# perceptron_core_0.tanh_ota_0.V_in_n 0.01441f
C90 perceptron_core_0.tanh_ota_0.V_ref perceptron_core_0.tanh_ota_0.V_in_n 6.49808f
C91 VDD a_67218_55696# 0.08026f
C92 a_49921_49178# perceptron_core_0.tanh_ota_0.V_ref 0.01755f
C93 a_44174_64480# a_44195_67876# 0.7754f
C94 a_43293_63442# perceptron_core_0.tanh_ota_0.V_in_p 0.31773f
C95 perceptron_core_0.gilbert_multiplier_current_2.V_x_n a_43293_63442# 0.3651f
C96 perceptron_core_0.gilbert_multiplier_current_1.V_x_n a_44174_53200# 0.04166f
C97 V_out_perceptron_core a_53826_51058# 0.13171f
C98 a_43293_63442# a_44195_67876# 0
C99 a_60034_62184# a_60034_60480# 0.0161f
C100 V_w1_core VDD 39.5499f
C101 perceptron_core_0.voltage_reference_0.v_1_25 a_43293_61004# 0.00402f
C102 perceptron_core_0.voltage_reference_0.v_1_15 a_60490_53140# 0.03725f
C103 a_48931_54374# a_49772_52654# 0
C104 V_out_perceptron_core a_53958_65406# 0.00195f
C105 perceptron_core_0.voltage_reference_0.v_1_25 a_55134_65510# 1.47413f
C106 perceptron_core_0.tanh_ota_0.V_in_n a_43991_66200# 2.16944f
C107 a_53906_56548# a_53906_54844# 0.00587f
C108 a_48233_51616# a_49772_52654# 0.23395f
C109 a_55134_51058# a_60490_54844# 0.0161f
C110 a_48931_54374# a_48233_51616# 0.77621f
C111 a_49077_51616# perceptron_core_0.tanh_ota_0.V_ref 0.03259f
C112 VDD I_x2 19.3964f
C113 a_54068_69233# a_55134_65510# 0.03312f
C114 perceptron_core_0.voltage_reference_0.v_1_25 a_55266_65406# 0.2801f
C115 perceptron_core_0.tanh_ota_0.V_ref perceptron_core_0.voltage_reference_0.v_1_15 0.14918f
C116 a_53906_63036# a_53906_61332# 0.00587f
C117 perceptron_core_0.voltage_reference_0.v_1_15 a_67218_53992# 0.02284f
C118 perceptron_core_0.gilbert_multiplier_current_1.V_x_n perceptron_core_0.voltage_reference_0.v_1_25 0.21459f
C119 a_48233_49178# perceptron_core_0.tanh_ota_0.V_ref 0.01755f
C120 perceptron_core_0.voltage_reference_0.v_1_25 a_53826_51058# 0.07725f
C121 a_54068_69233# a_55266_65406# 1.10709f
C122 perceptron_core_0.gilbert_multiplier_current_1.V_x_n V_w2_core 0.00333f
C123 a_60034_62184# VDD 0.09195f
C124 a_48931_54374# a_49529_59702# 0.00419f
C125 perceptron_core_0.tanh_ota_0.V_in_n a_47887_69308# 0.00281f
C126 a_44174_64480# perceptron_core_0.tanh_ota_0.V_in_n 0.10508f
C127 a_55134_51058# a_53906_54844# 0.00953f
C128 V_out_perceptron_core a_50381_62830# 0.06311f
C129 perceptron_core_0.voltage_reference_0.v_1_25 a_53958_65406# 1.04852f
C130 V_b_core perceptron_core_0.tanh_ota_0.V_ref 4.01697f
C131 a_53826_51058# a_53906_54844# 0.02924f
C132 perceptron_core_0.gilbert_multiplier_current_1.V_x_n a_44195_47782# 0
C133 perceptron_core_0.tanh_ota_0.V_in_p VDD 0.11052f
C134 perceptron_core_0.voltage_reference_0.v_1_15 a_60034_53992# 0.01849f
C135 perceptron_core_0.voltage_reference_0.v_1_25 I_x1_core 0.20987f
C136 perceptron_core_0.voltage_reference_0.v_1_25 V_shift_core 0.09992f
C137 V_out_perceptron_core a_49529_59702# 0
C138 a_54068_69233# a_53958_65406# 0.2532f
C139 perceptron_core_0.gilbert_multiplier_current_1.V_x_n a_43991_51280# 0.16229f
C140 a_44981_61004# a_43293_61004# 0.01656f
C141 perceptron_core_0.tanh_ota_0.V_ref a_49135_56824# 0.98267f
C142 a_44195_67876# VDD 0.00546f
C143 a_60034_55696# a_60034_53992# 0.0161f
C144 perceptron_core_0.voltage_reference_0.v_1_25 a_49772_52654# 0
C145 a_48931_54374# perceptron_core_0.voltage_reference_0.v_1_25 0.16254f
C146 VDD V_w2 19.3969f
C147 V_b_core I_x2_core 1.35461f
C148 perceptron_core_0.tanh_ota_0.V_in_p V_w1_core 1.09485f
C149 perceptron_core_0.gilbert_multiplier_current_2.V_x_n V_w1_core 0.00333f
C150 a_54068_46311# a_55266_50954# 1.10709f
C151 a_50871_64476# a_53826_51058# 0
C152 perceptron_core_0.voltage_reference_0.v_1_25 a_48233_51616# 0.37895f
C153 a_60034_57400# VDD 6.14308f
C154 a_64353_58580# a_67218_61332# 0
C155 a_44195_67876# V_w1_core 0.71915f
C156 a_54068_46311# a_53958_50954# 0.2532f
C157 a_55266_50954# VDD 6.6799f
C158 perceptron_core_0.voltage_reference_0.v_1_25 V_out_perceptron_core 0.09239f
C159 perceptron_core_0.voltage_reference_0.v_1_25 a_44174_53200# 0.72971f
C160 perceptron_core_0.gilbert_multiplier_current_1.V_x_n a_44137_54910# 0
C161 a_53958_50954# VDD 0.00179f
C162 a_54068_69233# V_out_perceptron_core 0.00194f
C163 a_52131_62540# a_53826_51058# 0.22118f
C164 a_55134_51058# perceptron_core_0.tanh_ota_0.V_ref 1.47413f
C165 perceptron_core_0.gilbert_multiplier_current_1.V_x_n perceptron_core_0.tanh_ota_0.V_ref 0.03504f
C166 a_44174_53200# a_44195_47782# 0.77598f
C167 perceptron_core_0.tanh_ota_0.V_ref a_53826_51058# 0.39048f
C168 a_48342_63968# V_shift_core 0.00117f
C169 a_52131_62540# a_53958_65406# 0
C170 perceptron_core_0.gilbert_multiplier_current_1.V_x_n a_43293_54910# 0.3651f
C171 a_44174_53200# a_43991_51280# 0
C172 perceptron_core_0.tanh_ota_0.V_in_n VDD 1.16046f
C173 a_50871_64476# a_50381_62830# 0
C174 perceptron_core_0.gilbert_multiplier_current_2.V_x_n perceptron_core_0.tanh_ota_0.V_in_p 0.25121f
C175 perceptron_core_0.gilbert_multiplier_current_1.V_x_n I_x2_core 0.52208f
C176 a_50871_64476# V_out_perceptron_core 0.75246f
C177 perceptron_core_0.voltage_reference_0.v_1_25 V_w2_core 0.00333f
C178 a_44195_67876# perceptron_core_0.tanh_ota_0.V_in_p 2.13719f
C179 a_48342_63968# a_50381_62830# 0.00182f
C180 perceptron_core_0.tanh_ota_0.V_in_n V_w1_core 1.32892f
C181 perceptron_core_0.gilbert_multiplier_current_2.V_x_n a_44195_67876# 0
C182 a_54068_69233# perceptron_core_0.voltage_reference_0.v_1_25 3.7839f
C183 a_48342_63968# V_out_perceptron_core 2.12528f
C184 perceptron_core_0.gilbert_multiplier_current_1.V_x_n a_43293_57348# 0.05238f
C185 perceptron_core_0.tanh_ota_0.V_ref a_49772_52654# 0.46508f
C186 a_48931_54374# perceptron_core_0.tanh_ota_0.V_ref 0.88892f
C187 VDD I_x1 20.4084f
C188 perceptron_core_0.voltage_reference_0.v_1_25 a_44195_47782# 0.16254f
C189 a_44195_47782# V_w2_core 0.71689f
C190 a_52131_62540# a_50381_62830# 0.0059f
C191 a_44137_54910# a_44174_53200# 0.02791f
C192 perceptron_core_0.tanh_ota_0.V_ref a_48233_51616# 0.34683f
C193 a_55134_65510# a_53906_61332# 0.0074f
C194 a_52131_62540# V_out_perceptron_core 0.03103f
C195 V_w1_core I_x1 0.70088f
C196 a_43991_51280# V_w2_core 0.65431f
C197 a_62490_63888# a_62490_62184# 0.0161f
C198 a_47887_67604# perceptron_core_0.voltage_reference_0.v_1_25 0.10628f
C199 V_out_perceptron_core perceptron_core_0.tanh_ota_0.V_ref 0
C200 a_44137_63442# perceptron_core_0.voltage_reference_0.v_1_25 0
C201 perceptron_core_0.tanh_ota_0.V_ref a_44174_53200# 0.46973f
C202 VDD perceptron_core_0.voltage_reference_0.v_1_15 1.2947f
C203 perceptron_core_0.voltage_reference_0.v_1_15 a_67218_55696# 0.02041f
C204 a_60490_54844# a_60490_53140# 0.0161f
C205 perceptron_core_0.tanh_ota_0.V_ref a_49529_59702# 0.02255f
C206 V_out_perceptron_core a_52415_68456# 0.00247f
C207 a_43991_51280# a_44195_47782# 0.13501f
C208 V_out_perceptron_core a_52415_70160# 0.00296f
C209 perceptron_core_0.voltage_reference_0.v_1_25 a_44981_57348# 0.02497f
C210 a_43293_54910# a_44174_53200# 0.23395f
C211 VDD a_60034_55696# 0.07587f
C212 VDD a_64353_58580# 1.45789f
C213 a_48342_63968# perceptron_core_0.voltage_reference_0.v_1_25 0
C214 a_64353_58580# a_67218_55696# 0
C215 a_53826_51058# a_53906_61332# 0.03953f
C216 V_b_core VDD 38.9012f
C217 perceptron_core_0.voltage_reference_0.v_1_25 a_44137_54910# 0
C218 VDD a_62775_58580# 1.80269f
C219 a_44981_61004# perceptron_core_0.voltage_reference_0.v_1_25 0.02497f
C220 perceptron_core_0.tanh_ota_0.V_in_n perceptron_core_0.tanh_ota_0.V_in_p 8.79808f
C221 perceptron_core_0.voltage_reference_0.v_1_25 a_52131_62540# 0.0254f
C222 perceptron_core_0.voltage_reference_0.v_1_25 perceptron_core_0.tanh_ota_0.V_ref 1.59128f
C223 a_53958_50954# a_55266_50954# 0.41277f
C224 perceptron_core_0.tanh_ota_0.V_in_n a_44195_67876# 2.37371f
C225 perceptron_core_0.tanh_ota_0.V_ref V_w2_core 3.92601f
C226 perceptron_core_0.voltage_reference_0.v_1_25 a_52415_68456# 0.05065f
C227 perceptron_core_0.voltage_reference_0.v_1_25 a_43293_54910# 0
C228 a_60490_54844# a_60034_53992# 0.08585f
C229 perceptron_core_0.tanh_ota_0.V_ref a_44195_47782# 0.92892f
C230 a_60043_58514# a_60034_60480# 0.00264f
C231 a_48342_63968# a_50871_64476# 1.10067f
C232 a_54068_69233# a_52415_68456# 0.00156f
C233 a_55134_65510# VDD 0.09051f
C234 perceptron_core_0.voltage_reference_0.v_1_25 I_x2_core 0.20987f
C235 a_54068_69233# a_52415_70160# 0.00339f
C236 a_43293_54910# a_44195_47782# 0
C237 perceptron_core_0.tanh_ota_0.V_ref a_43991_51280# 0.75193f
C238 a_60430_60950# a_60034_60480# 0.02115f
C239 a_55134_51058# a_54068_46311# 0.03312f
C240 a_55266_65406# VDD 6.6799f
C241 a_50871_64476# a_52131_62540# 0.17848f
C242 V_out_perceptron_core a_53906_61332# 0.00214f
C243 perceptron_core_0.voltage_reference_0.v_1_25 a_43293_57348# 0.0064f
C244 perceptron_core_0.tanh_ota_0.V_in_p perceptron_core_0.voltage_reference_0.v_1_15 0
C245 a_44137_63442# perceptron_core_0.tanh_ota_0.V_ref 0.03093f
C246 a_43293_54910# a_43991_51280# 0.77529f
C247 a_55134_51058# VDD 0.07822f
C248 a_48342_63968# a_52131_62540# 0.03652f
C249 perceptron_core_0.tanh_ota_0.V_ref a_44981_57348# 0.00372f
C250 a_48342_63968# perceptron_core_0.tanh_ota_0.V_ref 0.06904f
C251 V_b_core perceptron_core_0.tanh_ota_0.V_in_p 2.43096f
C252 a_60043_58514# VDD 0.39186f
C253 perceptron_core_0.voltage_reference_0.v_1_25 a_47887_69308# 0.00294f
C254 V_b_core perceptron_core_0.gilbert_multiplier_current_2.V_x_n 0
C255 perceptron_core_0.voltage_reference_0.v_1_25 a_44174_64480# 0.61396f
C256 a_53958_65406# VDD 0.00179f
C257 perceptron_core_0.tanh_ota_0.V_ref a_44137_54910# 0.03093f
C258 a_60034_57400# perceptron_core_0.voltage_reference_0.v_1_15 0.01193f
C259 a_62490_62184# a_55134_65510# 0.00325f
C260 a_44981_61004# perceptron_core_0.tanh_ota_0.V_ref 0.00372f
C261 a_60430_60950# VDD 1.69864f
C262 V_shift_core VDD 39.743f
C263 I_x1_core VDD 38.9012f
C264 a_55266_50954# perceptron_core_0.voltage_reference_0.v_1_15 0.05968f
C265 perceptron_core_0.voltage_reference_0.v_1_25 a_43293_63442# 0
C266 a_43293_54910# a_44137_54910# 0.02724f
C267 perceptron_core_0.tanh_ota_0.V_in_p a_49135_56824# 2.58855f
C268 a_60034_57400# a_60034_55696# 0.01841f
C269 a_60034_62184# a_55134_65510# 0.08837f
C270 a_52131_62540# a_52415_68456# 0.0161f
C271 a_60034_53992# a_60490_53140# 0.08585f
C272 a_43293_61004# perceptron_core_0.tanh_ota_0.V_in_p 0.01311f
C273 a_53958_50954# perceptron_core_0.voltage_reference_0.v_1_15 0.05166f
C274 perceptron_core_0.gilbert_multiplier_current_2.V_x_n a_43293_61004# 0.05207f
C275 a_43293_57348# a_44981_57348# 0.01656f
C276 V_shift_core V_w1_core 0.6393f
C277 perceptron_core_0.tanh_ota_0.V_ref a_43293_54910# 0.26733f
C278 a_60034_57400# a_62775_58580# 0.65869f
C279 a_47887_67604# a_47887_69308# 0.0161f
C280 a_52415_70160# a_52415_68456# 0.0161f
C281 a_44137_63442# a_44174_64480# 0.02791f
C282 V_out_perceptron_core VDD 41.5047f
C283 perceptron_core_0.tanh_ota_0.V_ref a_43991_66200# 0.7469f
C284 a_44137_63442# a_43293_63442# 0.02724f
C285 a_60430_60950# a_62490_62184# 0.0161f
C286 a_48233_49178# a_49921_49178# 0.01656f
C287 perceptron_core_0.gilbert_multiplier_current_1.V_x_n perceptron_core_0.tanh_ota_0.V_in_p 0.20574f
C288 VDD V_w1 19.389f
C289 perceptron_core_0.gilbert_multiplier_current_1.V_x_n perceptron_core_0.gilbert_multiplier_current_2.V_x_n 0
C290 V_b_core perceptron_core_0.tanh_ota_0.V_in_n 1.55496f
C291 VDD a_60490_54844# 0.01292f
C292 I_x2_core a_43293_57348# 0.00139f
C293 a_44174_64480# perceptron_core_0.tanh_ota_0.V_ref 0.45119f
C294 a_53906_63036# a_55134_65510# 0.01007f
C295 perceptron_core_0.voltage_reference_0.v_1_25 VDD 6.79869f
C296 I_x1_core perceptron_core_0.tanh_ota_0.V_in_p 0.12135f
C297 V_shift_core perceptron_core_0.tanh_ota_0.V_in_p 0.04934f
C298 perceptron_core_0.tanh_ota_0.V_in_n a_49135_56824# 2.16944f
C299 a_55134_51058# a_60034_57400# 0.03563f
C300 a_52131_62540# a_53906_61332# 0
C301 I_x1_core perceptron_core_0.gilbert_multiplier_current_2.V_x_n 0.52208f
C302 VDD V_w2_core 38.9038f
C303 a_43293_63442# perceptron_core_0.tanh_ota_0.V_ref 0.26229f
C304 a_55134_51058# a_55266_50954# 0.54051f
C305 perceptron_core_0.tanh_ota_0.V_in_p a_49772_52654# 0
C306 a_48931_54374# perceptron_core_0.tanh_ota_0.V_in_p 2.00137f
C307 a_54068_69233# VDD 4.32068f
C308 a_60043_58514# a_60034_57400# 0.01424f
C309 perceptron_core_0.voltage_reference_0.v_1_25 V_w1_core 0.00333f
C310 a_55134_51058# a_53958_50954# 0.55708f
C311 a_53906_63036# a_53826_51058# 0.02924f
C312 a_64353_58580# perceptron_core_0.voltage_reference_0.v_1_15 0.84737f
C313 VDD V_shift 19.389f
C314 a_53958_50954# a_53826_51058# 0.70424f
C315 perceptron_core_0.tanh_ota_0.V_in_p a_50381_62830# 0.0388f
C316 a_60430_60950# a_60034_57400# 0.06245f
C317 a_44174_64480# a_43991_66200# 0
C318 V_b_core perceptron_core_0.voltage_reference_0.v_1_15 0.00333f
C319 V_out_perceptron_core perceptron_core_0.tanh_ota_0.V_in_p 0.13196f
C320 a_53906_63036# a_53958_65406# 0
C321 a_62775_58580# perceptron_core_0.voltage_reference_0.v_1_15 1.5168f
C322 a_47887_67604# VDD 0.23421f
C323 perceptron_core_0.tanh_ota_0.V_in_p a_49529_59702# 0.08037f
C324 a_43293_63442# a_43991_66200# 0.77452f
C325 a_49135_56824# perceptron_core_0.voltage_reference_0.v_1_15 0.16229f
C326 a_62775_58580# a_64353_58580# 0.99499f
C327 VDD a_60490_53140# 0.0373f
C328 a_48342_63968# VDD 7.56513f
C329 a_54068_46311# perceptron_core_0.tanh_ota_0.V_ref 3.7839f
C330 a_43293_63442# a_44174_64480# 0.23395f
C331 V_b_core a_49135_56824# 0.65271f
C332 V_shift_core perceptron_core_0.tanh_ota_0.V_in_n 0.03881f
C333 perceptron_core_0.voltage_reference_0.v_1_25 perceptron_core_0.tanh_ota_0.V_in_p 0.44798f
C334 VDD V_out_perceptron 19.389f
C335 perceptron_core_0.voltage_reference_0.v_1_25 perceptron_core_0.gilbert_multiplier_current_2.V_x_n 0.21462f
C336 perceptron_core_0.tanh_ota_0.V_ref VDD 6.5962f
C337 perceptron_core_0.tanh_ota_0.V_in_p V_w2_core 1.12751f
C338 V_w2 VSS 23.80849f
C339 I_x2 VSS 23.80935f
C340 V_b VSS 23.81652f
C341 I_x1 VSS 49.97176f
C342 V_out_perceptron VSS 21.68597f
C343 V_shift VSS 21.60573f
C344 V_w1 VSS 23.81654f
C345 VDD VSS 1.82299p
C346 a_54068_46311# VSS 6.90433f
C347 a_55266_50954# VSS 1.43767f
C348 a_53958_50954# VSS 1.63765f
C349 a_49921_49178# VSS 1.3734f
C350 a_49077_51616# VSS 1.59945f
C351 a_48233_49178# VSS 1.37744f
C352 V_w2_core VSS 85.848f
C353 a_44195_47782# VSS 3.2564f
C354 a_43991_51280# VSS 2.66531f
C355 a_60490_53140# VSS 1.26323f
C356 a_67218_53992# VSS 1.52344f
C357 a_60034_53992# VSS 1.15657f
C358 a_49772_52654# VSS 2.86328f
C359 a_48233_51616# VSS 3.44657f
C360 a_44174_53200# VSS 3.30825f
C361 a_60490_54844# VSS 1.22088f
C362 a_53906_54844# VSS 1.66578f
C363 a_67218_55696# VSS 1.64278f
C364 a_60034_55696# VSS 1.25524f
C365 a_53906_56548# VSS 1.67099f
C366 perceptron_core_0.voltage_reference_0.v_1_15 VSS 8.23164f
C367 a_64353_58580# VSS 4.54862f
C368 a_62775_58580# VSS 0.12817f
C369 a_49135_56824# VSS 2.47344f
C370 a_44981_57348# VSS 1.36843f
C371 a_44137_54910# VSS 1.59921f
C372 a_43293_54910# VSS 2.68403f
C373 a_43293_57348# VSS 1.42226f
C374 a_60034_57400# VSS 1.70911f
C375 a_55134_51058# VSS 9.00053f
C376 a_60043_58514# VSS 1.06213f
C377 a_48931_54374# VSS 3.16083f
C378 perceptron_core_0.gilbert_multiplier_current_1.V_x_n VSS 5.12409f
C379 a_60430_60950# VSS 3.18764f
C380 a_67218_61332# VSS 1.72144f
C381 a_60034_60480# VSS 1.30485f
C382 a_53906_61332# VSS 1.80316f
C383 a_62490_62184# VSS 1.38373f
C384 a_60034_62184# VSS 1.29609f
C385 a_67218_63036# VSS 1.61377f
C386 a_53906_63036# VSS 1.65403f
C387 a_62490_63888# VSS 1.37777f
C388 a_55134_65510# VSS 9.0181f
C389 a_55266_65406# VSS 1.43767f
C390 a_53826_51058# VSS 17.2623f
C391 a_53958_65406# VSS 1.68973f
C392 a_50381_62830# VSS 1.58768f
C393 a_49529_59702# VSS 1.38267f
C394 a_50871_64476# VSS 0.59657f
C395 a_48342_63968# VSS 1.44377f
C396 a_44981_61004# VSS 1.36822f
C397 a_44137_63442# VSS 1.59946f
C398 a_43293_61004# VSS 1.43413f
C399 I_x2_core VSS 76.41261f
C400 a_44174_64480# VSS 3.32452f
C401 a_43293_63442# VSS 2.6771f
C402 perceptron_core_0.gilbert_multiplier_current_2.V_x_n VSS 5.12717f
C403 a_52131_62540# VSS 12.766f
C404 perceptron_core_0.voltage_reference_0.v_1_25 VSS 21.9821f
C405 a_54068_69233# VSS 6.85617f
C406 a_47887_67604# VSS 1.21892f
C407 a_52415_68456# VSS 1.59488f
C408 a_43991_66200# VSS 2.66531f
C409 a_47887_69308# VSS 1.20881f
C410 perceptron_core_0.tanh_ota_0.V_in_p VSS 18.4333f
C411 a_44195_67876# VSS 3.1909f
C412 perceptron_core_0.tanh_ota_0.V_in_n VSS 12.9603f
C413 perceptron_core_0.tanh_ota_0.V_ref VSS 46.3341f
C414 a_52415_70160# VSS 1.60478f
C415 V_b_core VSS 86.1644f
C416 I_x1_core VSS 77.8353f
C417 V_out_perceptron_core VSS 82.79739f
C418 V_shift_core VSS 82.0301f
C419 V_w1_core VSS 90.03629f
C420 VDD.n0 VSS 0.64001f
C421 VDD.t90 VSS 3.6106f
C422 VDD.n3 VSS 0.70451f
C423 VDD.n4 VSS 0.12799f
C424 VDD.n5 VSS 1.98574f
C425 VDD.n6 VSS 1.22812f
C426 VDD.n7 VSS 0.7213f
C427 VDD.n8 VSS 0.12799f
C428 VDD.n9 VSS 1.98574f
C429 VDD.n10 VSS 4.35741f
C430 VDD.n11 VSS 1.43144f
C431 VDD.n12 VSS 0.67098f
C432 VDD.n13 VSS 0.24517f
C433 VDD.n14 VSS 0.03236f
C434 VDD.n15 VSS 0.03236f
C435 VDD.n16 VSS 0.03236f
C436 VDD.n17 VSS 0.03236f
C437 VDD.n18 VSS 0.03236f
C438 VDD.n19 VSS 0.03236f
C439 VDD.n20 VSS 0.03236f
C440 VDD.n21 VSS 0.03236f
C441 VDD.n22 VSS 0.03236f
C442 VDD.n23 VSS 0.03236f
C443 VDD.n24 VSS 0.03236f
C444 VDD.n25 VSS 0.03236f
C445 VDD.n26 VSS 0.03236f
C446 VDD.n27 VSS 0.03236f
C447 VDD.n28 VSS 0.03236f
C448 VDD.n29 VSS 0.03236f
C449 VDD.n30 VSS 0.03236f
C450 VDD.n31 VSS 0.03236f
C451 VDD.n32 VSS 0.03236f
C452 VDD.n33 VSS 0.03236f
C453 VDD.n34 VSS 0.03236f
C454 VDD.n35 VSS 0.03236f
C455 VDD.n36 VSS 0.03236f
C456 VDD.n37 VSS 0.14012f
C457 VDD.n39 VSS 0.03236f
C458 VDD.n41 VSS 0.03236f
C459 VDD.n43 VSS 0.03236f
C460 VDD.n45 VSS 0.03236f
C461 VDD.n47 VSS 0.03236f
C462 VDD.n49 VSS 0.03236f
C463 VDD.n51 VSS 0.03236f
C464 VDD.n53 VSS 0.03236f
C465 VDD.n55 VSS 0.03236f
C466 VDD.n57 VSS 0.03236f
C467 VDD.n59 VSS 0.03236f
C468 VDD.n61 VSS 0.03236f
C469 VDD.n63 VSS 0.03236f
C470 VDD.n65 VSS 0.03236f
C471 VDD.n67 VSS 0.03236f
C472 VDD.n69 VSS 0.03236f
C473 VDD.n71 VSS 0.03236f
C474 VDD.n73 VSS 0.03236f
C475 VDD.n75 VSS 0.03236f
C476 VDD.n77 VSS 0.03236f
C477 VDD.n79 VSS 0.03236f
C478 VDD.n81 VSS 0.03236f
C479 VDD.n83 VSS 0.03236f
C480 VDD.n85 VSS 0.24517f
C481 VDD.n110 VSS 0.03228f
C482 VDD.n111 VSS 0.24517f
C483 VDD.n112 VSS 0.24517f
C484 VDD.n113 VSS 0.03228f
C485 VDD.n114 VSS 0.24517f
C486 VDD.n116 VSS 0.24517f
C487 VDD.n120 VSS 0.03228f
C488 VDD.n122 VSS 0.03228f
C489 VDD.n123 VSS 0.03228f
C490 VDD.n124 VSS 0.03228f
C491 VDD.n125 VSS 0.03228f
C492 VDD.n126 VSS 0.03228f
C493 VDD.n127 VSS 0.03228f
C494 VDD.n128 VSS 0.03228f
C495 VDD.n129 VSS 0.03228f
C496 VDD.n130 VSS 0.03228f
C497 VDD.n131 VSS 0.03228f
C498 VDD.n132 VSS 0.03228f
C499 VDD.n133 VSS 0.03228f
C500 VDD.n134 VSS 0.03228f
C501 VDD.n135 VSS 0.03228f
C502 VDD.n136 VSS 0.03228f
C503 VDD.n137 VSS 0.03228f
C504 VDD.n138 VSS 0.03228f
C505 VDD.n139 VSS 0.03228f
C506 VDD.n140 VSS 0.03228f
C507 VDD.n141 VSS 0.03228f
C508 VDD.n142 VSS 0.03228f
C509 VDD.n165 VSS 0.03228f
C510 VDD.n166 VSS 0.22587f
C511 VDD.n167 VSS 0.64001f
C512 VDD.n168 VSS 2.04149f
C513 VDD.n169 VSS 2.04149f
C514 VDD.n170 VSS 0.7213f
C515 VDD.n171 VSS 0.03274f
C516 VDD.n172 VSS 0.01639f
C517 VDD.n173 VSS 0.04103f
C518 VDD.n174 VSS 0.03901f
C519 VDD.n175 VSS 0.03901f
C520 VDD.n176 VSS 0.85875f
C521 VDD.n177 VSS 0.85875f
C522 VDD.n178 VSS 0.02543f
C523 VDD.n179 VSS 0.03901f
C524 VDD.n180 VSS 0.03901f
C525 VDD.n181 VSS 0.02502f
C526 VDD.n182 VSS 0.03901f
C527 VDD.n183 VSS 0.85875f
C528 VDD.n184 VSS 0.02543f
C529 VDD.n185 VSS 0.53437f
C530 VDD.n186 VSS 0.01639f
C531 VDD.n187 VSS 0.04103f
C532 VDD.n188 VSS 0.04984f
C533 VDD.n189 VSS 0.03389f
C534 VDD.n190 VSS 0.02519f
C535 VDD.n191 VSS 0.03943f
C536 VDD.t124 VSS 0.85904f
C537 VDD.n193 VSS 0.03943f
C538 VDD.n194 VSS 0.03901f
C539 VDD.n195 VSS 0.02629f
C540 VDD.t123 VSS 0.85875f
C541 VDD.n196 VSS 0.02629f
C542 VDD.n197 VSS 0.0168f
C543 VDD.n198 VSS 0.02502f
C544 VDD.n199 VSS 0.02543f
C545 VDD.n200 VSS 0.01639f
C546 VDD.n201 VSS 0.03397f
C547 VDD.n202 VSS 0.53437f
C548 VDD.n203 VSS 0.05f
C549 VDD.n204 VSS 0.03943f
C550 VDD.t121 VSS 0.85904f
C551 VDD.n206 VSS 0.03943f
C552 VDD.n207 VSS 0.02519f
C553 VDD.n208 VSS 0.02502f
C554 VDD.n209 VSS 0.0168f
C555 VDD.n210 VSS 0.02629f
C556 VDD.t122 VSS 0.85875f
C557 VDD.n211 VSS 0.02629f
C558 VDD.n212 VSS 0.03286f
C559 VDD.n213 VSS 0.02472f
C560 VDD.n214 VSS 0.04009f
C561 VDD.n215 VSS 3.51278f
C562 VDD.n216 VSS 0.64001f
C563 VDD.n217 VSS 2.04149f
C564 VDD.n218 VSS 2.04149f
C565 VDD.n219 VSS 0.03274f
C566 VDD.n220 VSS 0.01639f
C567 VDD.n221 VSS 0.04103f
C568 VDD.n222 VSS 0.03901f
C569 VDD.n223 VSS 0.03901f
C570 VDD.n224 VSS 0.85875f
C571 VDD.n225 VSS 0.85875f
C572 VDD.n226 VSS 0.02543f
C573 VDD.n227 VSS 0.03901f
C574 VDD.n228 VSS 0.03901f
C575 VDD.n229 VSS 0.02502f
C576 VDD.n230 VSS 0.03901f
C577 VDD.n231 VSS 0.85875f
C578 VDD.n232 VSS 0.02543f
C579 VDD.n233 VSS 0.53437f
C580 VDD.n234 VSS 0.01639f
C581 VDD.n235 VSS 0.04103f
C582 VDD.n236 VSS 0.04984f
C583 VDD.n237 VSS 0.03389f
C584 VDD.n238 VSS 0.02519f
C585 VDD.n239 VSS 0.03943f
C586 VDD.t17 VSS 0.85904f
C587 VDD.n241 VSS 0.03943f
C588 VDD.n242 VSS 0.03901f
C589 VDD.n243 VSS 0.02629f
C590 VDD.t16 VSS 0.85875f
C591 VDD.n244 VSS 0.02629f
C592 VDD.n245 VSS 0.0168f
C593 VDD.n246 VSS 0.02502f
C594 VDD.n247 VSS 0.02543f
C595 VDD.n248 VSS 0.01639f
C596 VDD.n249 VSS 0.03397f
C597 VDD.n250 VSS 0.53437f
C598 VDD.n251 VSS 0.05f
C599 VDD.n252 VSS 0.03943f
C600 VDD.t14 VSS 0.85904f
C601 VDD.n254 VSS 0.03943f
C602 VDD.n255 VSS 0.02519f
C603 VDD.n256 VSS 0.02502f
C604 VDD.n257 VSS 0.0168f
C605 VDD.n258 VSS 0.02629f
C606 VDD.t15 VSS 0.85875f
C607 VDD.n259 VSS 0.02629f
C608 VDD.n260 VSS 0.03286f
C609 VDD.n261 VSS 0.02472f
C610 VDD.n262 VSS 0.04009f
C611 VDD.n263 VSS 3.51278f
C612 VDD.n264 VSS 0.64001f
C613 VDD.n265 VSS 2.04149f
C614 VDD.n266 VSS 2.04149f
C615 VDD.n267 VSS 0.7213f
C616 VDD.n268 VSS 0.70451f
C617 VDD.n269 VSS 1.22812f
C618 VDD.n270 VSS 0.12891f
C619 VDD.t70 VSS 3.49727f
C620 VDD.n273 VSS 0.12891f
C621 VDD.n274 VSS 2.21664f
C622 VDD.n275 VSS 6.90874f
C623 VDD.n276 VSS 0.72107f
C624 VDD.n277 VSS 4.07497f
C625 VDD.n278 VSS 0.70451f
C626 VDD.n279 VSS 0.61194f
C627 VDD.n280 VSS 0.12891f
C628 VDD.t120 VSS 3.49727f
C629 VDD.n283 VSS 0.12891f
C630 VDD.n284 VSS 2.21664f
C631 VDD.n285 VSS 6.90874f
C632 VDD.n286 VSS 0.70165f
C633 VDD.n287 VSS 4.06843f
C634 VDD.n288 VSS 0.62111f
C635 VDD.n289 VSS 0.12891f
C636 VDD.t1 VSS 3.49727f
C637 VDD.n292 VSS 0.12891f
C638 VDD.n293 VSS 5.02898f
C639 VDD.n294 VSS 3.21983f
C640 VDD.n295 VSS 0.03274f
C641 VDD.n296 VSS 0.01639f
C642 VDD.n297 VSS 0.04103f
C643 VDD.n298 VSS 0.03901f
C644 VDD.n299 VSS 0.03901f
C645 VDD.n300 VSS 0.85875f
C646 VDD.n301 VSS 0.85875f
C647 VDD.n302 VSS 0.02543f
C648 VDD.n303 VSS 0.03901f
C649 VDD.n304 VSS 0.03901f
C650 VDD.n305 VSS 0.02502f
C651 VDD.n306 VSS 0.03901f
C652 VDD.n307 VSS 0.85875f
C653 VDD.n308 VSS 0.02543f
C654 VDD.n309 VSS 0.53437f
C655 VDD.n310 VSS 0.01639f
C656 VDD.n311 VSS 0.04103f
C657 VDD.n312 VSS 0.04984f
C658 VDD.n313 VSS 0.03389f
C659 VDD.n314 VSS 0.02519f
C660 VDD.n315 VSS 0.03943f
C661 VDD.t118 VSS 0.85904f
C662 VDD.n317 VSS 0.03943f
C663 VDD.n318 VSS 0.03901f
C664 VDD.n319 VSS 0.02629f
C665 VDD.t117 VSS 0.85875f
C666 VDD.n320 VSS 0.02629f
C667 VDD.n321 VSS 0.0168f
C668 VDD.n322 VSS 0.02502f
C669 VDD.n323 VSS 0.02543f
C670 VDD.n324 VSS 0.01639f
C671 VDD.n325 VSS 0.03397f
C672 VDD.n326 VSS 0.53437f
C673 VDD.n327 VSS 0.05f
C674 VDD.n328 VSS 0.03943f
C675 VDD.t115 VSS 0.85904f
C676 VDD.n330 VSS 0.03943f
C677 VDD.n331 VSS 0.02519f
C678 VDD.n332 VSS 0.02502f
C679 VDD.n333 VSS 0.0168f
C680 VDD.n334 VSS 0.02629f
C681 VDD.t116 VSS 0.85875f
C682 VDD.n335 VSS 0.02629f
C683 VDD.n336 VSS 0.03286f
C684 VDD.n337 VSS 0.02472f
C685 VDD.n338 VSS 0.01643f
C686 VDD.n339 VSS 0.53833f
C687 VDD.n340 VSS 0.0516f
C688 VDD.n341 VSS 0.04038f
C689 VDD.n342 VSS 0.23849f
C690 VDD.n343 VSS 12.0915f
C691 VDD.n344 VSS 7.89125f
C692 VDD.n345 VSS 0.03228f
C693 VDD.n346 VSS 0.24517f
C694 VDD.n347 VSS 0.24517f
C695 VDD.n348 VSS 0.03228f
C696 VDD.n350 VSS 0.24517f
C697 VDD.n353 VSS 0.24517f
C698 VDD.n356 VSS 0.03228f
C699 VDD.n357 VSS 0.03228f
C700 VDD.n358 VSS 0.03228f
C701 VDD.n359 VSS 0.03228f
C702 VDD.n360 VSS 0.03228f
C703 VDD.n361 VSS 0.03228f
C704 VDD.n362 VSS 0.03228f
C705 VDD.n363 VSS 0.03228f
C706 VDD.n364 VSS 0.03228f
C707 VDD.n365 VSS 0.03228f
C708 VDD.n366 VSS 0.03228f
C709 VDD.n367 VSS 0.03228f
C710 VDD.n368 VSS 0.03228f
C711 VDD.n369 VSS 0.03228f
C712 VDD.n370 VSS 0.03228f
C713 VDD.n371 VSS 0.03228f
C714 VDD.n372 VSS 0.03228f
C715 VDD.n373 VSS 0.03228f
C716 VDD.n374 VSS 0.03228f
C717 VDD.n375 VSS 0.03228f
C718 VDD.n376 VSS 0.03228f
C719 VDD.n379 VSS 0.03228f
C720 VDD.n381 VSS 0.03228f
C721 VDD.n383 VSS 0.03228f
C722 VDD.n385 VSS 0.03228f
C723 VDD.n387 VSS 0.03228f
C724 VDD.n389 VSS 0.03228f
C725 VDD.n391 VSS 0.03228f
C726 VDD.n393 VSS 0.03228f
C727 VDD.n395 VSS 0.03228f
C728 VDD.n397 VSS 0.03228f
C729 VDD.n399 VSS 0.03228f
C730 VDD.n401 VSS 0.03228f
C731 VDD.n403 VSS 0.03228f
C732 VDD.n405 VSS 0.03228f
C733 VDD.n407 VSS 0.03228f
C734 VDD.n409 VSS 0.03228f
C735 VDD.n411 VSS 0.03228f
C736 VDD.n413 VSS 0.03228f
C737 VDD.n415 VSS 0.03228f
C738 VDD.n417 VSS 0.03228f
C739 VDD.n419 VSS 0.03228f
C740 VDD.n420 VSS 0.31832f
C741 VDD.n421 VSS 0.06612f
C742 VDD.n422 VSS 43.5101f
C743 VDD.n423 VSS 0
C744 VDD.n424 VSS 0.01098f
C745 VDD.n425 VSS 0.00328f
C746 VDD.n426 VSS 0
C747 VDD.n427 VSS 0.01375f
C748 VDD.n428 VSS 0.00331f
C749 VDD.n429 VSS 0.00338f
C750 VDD.n430 VSS 0.01698f
C751 VDD.t34 VSS 0.02821f
C752 VDD.n431 VSS 0.03161f
C753 VDD.t95 VSS 0.00857f
C754 VDD.t97 VSS 0.00857f
C755 VDD.n432 VSS 0.02776f
C756 VDD.t103 VSS 0.00857f
C757 VDD.t105 VSS 0.00857f
C758 VDD.n433 VSS 0.02776f
C759 VDD.t99 VSS 0.00857f
C760 VDD.t107 VSS 0.00857f
C761 VDD.n434 VSS 0.02776f
C762 VDD.n435 VSS 0.08644f
C763 VDD.n436 VSS 0.23166f
C764 VDD.n437 VSS 0.23018f
C765 VDD.t33 VSS 0.16467f
C766 VDD.t94 VSS 0.12934f
C767 VDD.t96 VSS 0.12934f
C768 VDD.t102 VSS 0.12934f
C769 VDD.t104 VSS 0.1062f
C770 VDD.t36 VSS 0.16467f
C771 VDD.t100 VSS 0.12934f
C772 VDD.t108 VSS 0.12934f
C773 VDD.t106 VSS 0.12934f
C774 VDD.t98 VSS 0.08781f
C775 VDD.n438 VSS 0.02786f
C776 VDD.n439 VSS 0.01202f
C777 VDD.t32 VSS 0.0261f
C778 VDD.n440 VSS 0.0425f
C779 VDD.t35 VSS 0.0261f
C780 VDD.n441 VSS 0.0425f
C781 VDD.n442 VSS 0.01202f
C782 VDD.t37 VSS 0.02821f
C783 VDD.n443 VSS 0.03161f
C784 VDD.t109 VSS 0.00857f
C785 VDD.t101 VSS 0.00857f
C786 VDD.n444 VSS 0.02776f
C787 VDD.n445 VSS 0.1184f
C788 VDD.n446 VSS 0.12207f
C789 VDD.n447 VSS 0.01794f
C790 VDD.n448 VSS 0.0275f
C791 VDD.n449 VSS 0.03722f
C792 VDD.n450 VSS 0.05201f
C793 VDD.n451 VSS 0.06467f
C794 VDD.n452 VSS 0.05124f
C795 VDD.n453 VSS 0.0246f
C796 VDD.n454 VSS 0.08993f
C797 VDD.n455 VSS 0.1184f
C798 VDD.n456 VSS 0.08256f
C799 VDD.n457 VSS 0.04907f
C800 VDD.t0 VSS 0.01863f
C801 VDD.n458 VSS 0.14694f
C802 VDD.t13 VSS 0.01863f
C803 VDD.n459 VSS 0.09623f
C804 VDD.n460 VSS 0.01327f
C805 VDD.n461 VSS 0.00585f
C806 VDD.n462 VSS 0.4636f
C807 VDD.n463 VSS 0.31797f
C808 VDD.n464 VSS 0.01796f
C809 VDD.t29 VSS 0.2063f
C810 VDD.t31 VSS 0.10291f
C811 VDD.n465 VSS 0.11312f
C812 VDD.n466 VSS 0.02339f
C813 VDD.n467 VSS 0.38645f
C814 VDD.n468 VSS 0.38792f
C815 VDD.t27 VSS 0.42521f
C816 VDD.t20 VSS 0.44227f
C817 VDD.t18 VSS 0.31898f
C818 VDD.n469 VSS 0.04738f
C819 VDD.n470 VSS 0.01527f
C820 VDD.t12 VSS 0.01714f
C821 VDD.t68 VSS 0.01714f
C822 VDD.n471 VSS 0.03427f
C823 VDD.n472 VSS 0.04555f
C824 VDD.t112 VSS 0.01714f
C825 VDD.t3 VSS 0.01714f
C826 VDD.n473 VSS 0.03427f
C827 VDD.n474 VSS 0.04555f
C828 VDD.n475 VSS 0.025f
C829 VDD.t4 VSS 0.01714f
C830 VDD.t5 VSS 0.01714f
C831 VDD.n476 VSS 0.03427f
C832 VDD.n477 VSS 0.04304f
C833 VDD.n478 VSS 0.02738f
C834 VDD.n479 VSS 0.01146f
C835 VDD.t6 VSS 0.01714f
C836 VDD.t7 VSS 0.01714f
C837 VDD.n480 VSS 0.03427f
C838 VDD.n481 VSS 0.04304f
C839 VDD.n482 VSS 0.01765f
C840 VDD.t8 VSS 0.01714f
C841 VDD.t9 VSS 0.01714f
C842 VDD.n483 VSS 0.03427f
C843 VDD.n484 VSS 0.04304f
C844 VDD.n485 VSS 0.01765f
C845 VDD.n486 VSS 0.02738f
C846 VDD.t10 VSS 0.01714f
C847 VDD.t11 VSS 0.01714f
C848 VDD.n487 VSS 0.03427f
C849 VDD.n488 VSS 0.04304f
C850 VDD.n489 VSS 0.0212f
C851 VDD.n490 VSS 0.04323f
C852 VDD.n491 VSS 0.06173f
C853 VDD.n492 VSS 0.05177f
C854 VDD.t21 VSS 0.01714f
C855 VDD.t19 VSS 0.01714f
C856 VDD.n493 VSS 0.06662f
C857 VDD.n494 VSS 0.052f
C858 VDD.t23 VSS 0.01714f
C859 VDD.t25 VSS 0.01714f
C860 VDD.n495 VSS 0.06662f
C861 VDD.t38 VSS 0.2063f
C862 VDD.t40 VSS 0.10291f
C863 VDD.n496 VSS 0.11312f
C864 VDD.n497 VSS 0.02303f
C865 VDD.t60 VSS 0.01714f
C866 VDD.t62 VSS 0.01714f
C867 VDD.n498 VSS 0.06662f
C868 VDD.n499 VSS 0.05807f
C869 VDD.n500 VSS 0.07248f
C870 VDD.n501 VSS 0.07393f
C871 VDD.n502 VSS 0.01886f
C872 VDD.t56 VSS 0.2063f
C873 VDD.t58 VSS 0.10291f
C874 VDD.n503 VSS 0.11312f
C875 VDD.n504 VSS 0.03828f
C876 VDD.n505 VSS 0.04738f
C877 VDD.n506 VSS 0.0212f
C878 VDD.n507 VSS 0.01146f
C879 VDD.t69 VSS 0.01714f
C880 VDD.t80 VSS 0.01714f
C881 VDD.n508 VSS 0.03427f
C882 VDD.n509 VSS 0.04555f
C883 VDD.t81 VSS 0.01714f
C884 VDD.t82 VSS 0.01714f
C885 VDD.n510 VSS 0.03427f
C886 VDD.n511 VSS 0.04304f
C887 VDD.n512 VSS 0.02738f
C888 VDD.t89 VSS 0.01714f
C889 VDD.t67 VSS 0.01714f
C890 VDD.n513 VSS 0.03427f
C891 VDD.n514 VSS 0.04555f
C892 VDD.n515 VSS 0.025f
C893 VDD.t87 VSS 0.01714f
C894 VDD.t88 VSS 0.01714f
C895 VDD.n516 VSS 0.03427f
C896 VDD.n517 VSS 0.04304f
C897 VDD.n518 VSS 0.02738f
C898 VDD.t85 VSS 0.01714f
C899 VDD.t86 VSS 0.01714f
C900 VDD.n519 VSS 0.03427f
C901 VDD.n520 VSS 0.04304f
C902 VDD.n521 VSS 0.01765f
C903 VDD.n522 VSS 0.01765f
C904 VDD.t83 VSS 0.01714f
C905 VDD.t84 VSS 0.01714f
C906 VDD.n523 VSS 0.03427f
C907 VDD.n524 VSS 0.04304f
C908 VDD.n525 VSS 0.01527f
C909 VDD.n526 VSS 0.04323f
C910 VDD.n527 VSS 0.06173f
C911 VDD.t64 VSS 0.01714f
C912 VDD.t66 VSS 0.01714f
C913 VDD.n528 VSS 0.06662f
C914 VDD.n529 VSS 0.01167f
C915 VDD.n530 VSS 0.052f
C916 VDD.n531 VSS 0.05177f
C917 VDD.n532 VSS 0.02136f
C918 VDD.n533 VSS 0.38645f
C919 VDD.t57 VSS 0.42521f
C920 VDD.t65 VSS 0.44227f
C921 VDD.t63 VSS 0.31898f
C922 VDD.n534 VSS 0.22114f
C923 VDD.t61 VSS 0.34443f
C924 VDD.t59 VSS 0.44227f
C925 VDD.t39 VSS 0.42521f
C926 VDD.n535 VSS 0.38792f
C927 VDD.n536 VSS 0.04497f
C928 VDD.n537 VSS 0.07239f
C929 VDD.n538 VSS 0.09732f
C930 VDD.n539 VSS 0.01758f
C931 VDD.t41 VSS 0.05477f
C932 VDD.t43 VSS 0.02821f
C933 VDD.n540 VSS 0.03038f
C934 VDD.n541 VSS 0.03049f
C935 VDD.n542 VSS 0.01004f
C936 VDD.n543 VSS 0.03796f
C937 VDD.n544 VSS 0.03796f
C938 VDD.t50 VSS 0.05477f
C939 VDD.t51 VSS 0.04079f
C940 VDD.n545 VSS 0.0512f
C941 VDD.n546 VSS 0.01451f
C942 VDD.n547 VSS 0.09872f
C943 VDD.n548 VSS 0.03106f
C944 VDD.n549 VSS 0.03106f
C945 VDD.n550 VSS 0.54619f
C946 VDD.n551 VSS 0.02594f
C947 VDD.n552 VSS 0.02594f
C948 VDD.t71 VSS 0.00857f
C949 VDD.t76 VSS 0.00857f
C950 VDD.n553 VSS 0.02829f
C951 VDD.n554 VSS 0.03011f
C952 VDD.t77 VSS 0.00857f
C953 VDD.t78 VSS 0.00857f
C954 VDD.n555 VSS 0.02829f
C955 VDD.t54 VSS 0.10469f
C956 VDD.t55 VSS 0.10289f
C957 VDD.n556 VSS 0.07319f
C958 VDD.n557 VSS 0.01663f
C959 VDD.n558 VSS 0.64083f
C960 VDD.n559 VSS 0.02827f
C961 VDD.t2 VSS 0.51608f
C962 VDD.n560 VSS 0.01613f
C963 VDD.t119 VSS 0.06478f
C964 VDD.n561 VSS 0.11786f
C965 VDD.n562 VSS 0.0434f
C966 VDD.t52 VSS 0.10469f
C967 VDD.t53 VSS 0.10289f
C968 VDD.n563 VSS 0.07319f
C969 VDD.t47 VSS 0.05477f
C970 VDD.t49 VSS 0.04079f
C971 VDD.n564 VSS 0.0512f
C972 VDD.n565 VSS 0.01451f
C973 VDD.n566 VSS 0.01574f
C974 VDD.n567 VSS 0.01933f
C975 VDD.n568 VSS 0.00403f
C976 VDD.n569 VSS 0.01663f
C977 VDD.n570 VSS 0.04203f
C978 VDD.n571 VSS 0.04478f
C979 VDD.n572 VSS 0.54207f
C980 VDD.n573 VSS 0.04534f
C981 VDD.n574 VSS 0.01613f
C982 VDD.n575 VSS 0.00403f
C983 VDD.n576 VSS 0.01574f
C984 VDD.n577 VSS 0.01933f
C985 VDD.n578 VSS 0.03011f
C986 VDD.n579 VSS 0.00666f
C987 VDD.n580 VSS 0.03185f
C988 VDD.n581 VSS 0.31387f
C989 VDD.t48 VSS 0.28751f
C990 VDD.n582 VSS 0.30358f
C991 VDD.n584 VSS 0.43631f
C992 VDD.n585 VSS 0.18038f
C993 VDD.n586 VSS 0.09872f
C994 VDD.n587 VSS 0.01004f
C995 VDD.t73 VSS 0.00857f
C996 VDD.t75 VSS 0.00857f
C997 VDD.n588 VSS 0.02831f
C998 VDD.n589 VSS 0.0316f
C999 VDD.t44 VSS 0.05477f
C1000 VDD.n590 VSS 0.03049f
C1001 VDD.t46 VSS 0.02821f
C1002 VDD.n591 VSS 0.03038f
C1003 VDD.n592 VSS 0.01758f
C1004 VDD.n593 VSS 0.02862f
C1005 VDD.n594 VSS 0.01575f
C1006 VDD.n595 VSS 0.20493f
C1007 VDD.t45 VSS 0.18178f
C1008 VDD.t74 VSS 0.12382f
C1009 VDD.n596 VSS 0.08254f
C1010 VDD.t72 VSS 0.12382f
C1011 VDD.t42 VSS 0.18178f
C1012 VDD.n597 VSS 0.20493f
C1013 VDD.n598 VSS 0.01575f
C1014 VDD.n599 VSS 0.02862f
C1015 VDD.n600 VSS 0.09732f
C1016 VDD.t79 VSS 0.02988f
C1017 VDD.n601 VSS 0.10783f
C1018 VDD.n602 VSS 0.04497f
C1019 VDD.n603 VSS 0.05807f
C1020 VDD.n604 VSS 0.01167f
C1021 VDD.n605 VSS 0.07393f
C1022 VDD.t30 VSS 0.42521f
C1023 VDD.t24 VSS 0.44227f
C1024 VDD.t22 VSS 0.34443f
C1025 VDD.n606 VSS 0.22114f
C1026 VDD.n607 VSS 0.07248f
C1027 VDD.n608 VSS 0.03772f
C1028 VDD.t26 VSS 0.2063f
C1029 VDD.t28 VSS 0.10291f
C1030 VDD.n609 VSS 0.11312f
C1031 VDD.n610 VSS 0.02298f
C1032 VDD.n611 VSS 0.12195f
C1033 VDD.n612 VSS 0.1093f
C1034 VDD.n613 VSS 0.00415f
C1035 VDD.n614 VSS 0.09672f
C1036 VDD.n615 VSS 64.1083f
C1037 VDD.n616 VSS 0.22294f
C1038 VDD.n617 VSS 0.02472f
C1039 VDD.n618 VSS 0.04103f
C1040 VDD.n619 VSS 0.03943f
C1041 VDD.n620 VSS 0.03943f
C1042 VDD.n621 VSS 0.02543f
C1043 VDD.n622 VSS 0.03901f
C1044 VDD.t111 VSS 3.28602f
C1045 VDD.n623 VSS 0.05256f
C1046 VDD.n624 VSS 0.03943f
C1047 VDD.n625 VSS 0.03397f
C1048 VDD.n626 VSS 0.02519f
C1049 VDD.n627 VSS 0.02502f
C1050 VDD.n628 VSS 0.03901f
C1051 VDD.n629 VSS 0.03943f
C1052 VDD.n630 VSS 0.01645f
C1053 VDD.n631 VSS 0.03901f
C1054 VDD.n632 VSS 0.03943f
C1055 VDD.n633 VSS 0.02629f
C1056 VDD.n634 VSS 0.01657f
C1057 VDD.n635 VSS 0.02519f
C1058 VDD.n636 VSS 0.04984f
C1059 VDD.n637 VSS 0.05256f
C1060 VDD.n638 VSS 0.03389f
C1061 VDD.n639 VSS 0.02502f
C1062 VDD.n640 VSS 0.02629f
C1063 VDD.n641 VSS 0.01657f
C1064 VDD.n642 VSS 0.02519f
C1065 VDD.n643 VSS 0.01645f
C1066 VDD.n644 VSS 0.02543f
C1067 VDD.n645 VSS 1.84468f
C1068 VDD.n646 VSS 0.02543f
C1069 VDD.n647 VSS 0.03943f
C1070 VDD.n648 VSS 0.02629f
C1071 VDD.n649 VSS 0.01657f
C1072 VDD.n650 VSS 0.03286f
C1073 VDD.n651 VSS 0.04103f
C1074 VDD.n652 VSS 0.05f
C1075 VDD.n653 VSS 0.03901f
C1076 VDD.n654 VSS 1.84468f
C1077 VDD.n655 VSS 0.02543f
C1078 VDD.n656 VSS 0.03274f
C1079 VDD.n657 VSS 0.01643f
C1080 VDD.n658 VSS 0.51338f
C1081 VDD.n659 VSS 0.64001f
C1082 VDD.t110 VSS 3.6106f
C1083 VDD.n662 VSS 0.70451f
C1084 VDD.n663 VSS 0.12799f
C1085 VDD.n664 VSS 1.98574f
C1086 VDD.n665 VSS 1.22812f
C1087 VDD.n666 VSS 0.7213f
C1088 VDD.n667 VSS 0.12799f
C1089 VDD.n668 VSS 1.98574f
C1090 VDD.n669 VSS 5.02983f
C1091 VDD.n670 VSS 3.15547f
C1092 VDD.n671 VSS 0.22491f
C1093 VDD.n672 VSS 0.04978f
C1094 VDD.n673 VSS 0.03896f
C1095 VDD.n674 VSS 2.42899f
C1096 VDD.n675 VSS 0.02472f
C1097 VDD.n676 VSS 0.04103f
C1098 VDD.n677 VSS 0.03943f
C1099 VDD.n678 VSS 0.03943f
C1100 VDD.n679 VSS 0.02543f
C1101 VDD.n680 VSS 0.03901f
C1102 VDD.t92 VSS 3.28602f
C1103 VDD.n681 VSS 0.05256f
C1104 VDD.n682 VSS 0.03943f
C1105 VDD.n683 VSS 0.03397f
C1106 VDD.n684 VSS 0.02519f
C1107 VDD.n685 VSS 0.02502f
C1108 VDD.n686 VSS 0.03901f
C1109 VDD.n687 VSS 0.03943f
C1110 VDD.n688 VSS 0.01645f
C1111 VDD.n689 VSS 0.03901f
C1112 VDD.n690 VSS 0.03943f
C1113 VDD.n691 VSS 0.02629f
C1114 VDD.n692 VSS 0.01657f
C1115 VDD.n693 VSS 0.02519f
C1116 VDD.n694 VSS 0.04984f
C1117 VDD.n695 VSS 0.05256f
C1118 VDD.n696 VSS 0.03389f
C1119 VDD.n697 VSS 0.02502f
C1120 VDD.n698 VSS 0.02629f
C1121 VDD.n699 VSS 0.01657f
C1122 VDD.n700 VSS 0.02519f
C1123 VDD.n701 VSS 0.01645f
C1124 VDD.n702 VSS 0.02543f
C1125 VDD.n703 VSS 1.84468f
C1126 VDD.n704 VSS 0.02543f
C1127 VDD.n705 VSS 0.03943f
C1128 VDD.n706 VSS 0.02629f
C1129 VDD.n707 VSS 0.01657f
C1130 VDD.n708 VSS 0.03286f
C1131 VDD.n709 VSS 0.04103f
C1132 VDD.n710 VSS 0.05f
C1133 VDD.n711 VSS 0.03901f
C1134 VDD.n712 VSS 1.84468f
C1135 VDD.n713 VSS 0.02543f
C1136 VDD.n714 VSS 0.03274f
C1137 VDD.n715 VSS 0.04009f
C1138 VDD.n716 VSS 3.50866f
C1139 VDD.n717 VSS 0.64001f
C1140 VDD.t113 VSS 3.6106f
C1141 VDD.n720 VSS 0.70451f
C1142 VDD.n721 VSS 0.12799f
C1143 VDD.n722 VSS 1.98574f
C1144 VDD.n723 VSS 1.22812f
C1145 VDD.n724 VSS 0.7213f
C1146 VDD.n725 VSS 0.12799f
C1147 VDD.n726 VSS 1.98574f
C1148 VDD.n727 VSS 2.21664f
C1149 VDD.n728 VSS 4.31717f
C1150 VDD.n729 VSS 0.2229f
C1151 VDD.n730 VSS 0.02472f
C1152 VDD.n731 VSS 0.04103f
C1153 VDD.n732 VSS 0.03943f
C1154 VDD.n733 VSS 0.03943f
C1155 VDD.n734 VSS 0.02543f
C1156 VDD.n735 VSS 0.03901f
C1157 VDD.t91 VSS 3.28602f
C1158 VDD.n736 VSS 0.05256f
C1159 VDD.n737 VSS 0.03943f
C1160 VDD.n738 VSS 0.03397f
C1161 VDD.n739 VSS 0.02519f
C1162 VDD.n740 VSS 0.02502f
C1163 VDD.n741 VSS 0.03901f
C1164 VDD.n742 VSS 0.03943f
C1165 VDD.n743 VSS 0.01645f
C1166 VDD.n744 VSS 0.03901f
C1167 VDD.n745 VSS 0.03943f
C1168 VDD.n746 VSS 0.02629f
C1169 VDD.n747 VSS 0.01657f
C1170 VDD.n748 VSS 0.02519f
C1171 VDD.n749 VSS 0.04984f
C1172 VDD.n750 VSS 0.05256f
C1173 VDD.n751 VSS 0.03389f
C1174 VDD.n752 VSS 0.02502f
C1175 VDD.n753 VSS 0.02629f
C1176 VDD.n754 VSS 0.01657f
C1177 VDD.n755 VSS 0.02519f
C1178 VDD.n756 VSS 0.01645f
C1179 VDD.n757 VSS 0.02543f
C1180 VDD.n758 VSS 1.84468f
C1181 VDD.n759 VSS 0.02543f
C1182 VDD.n760 VSS 0.03943f
C1183 VDD.n761 VSS 0.02629f
C1184 VDD.n762 VSS 0.01657f
C1185 VDD.n763 VSS 0.03286f
C1186 VDD.n764 VSS 0.04103f
C1187 VDD.n765 VSS 0.05f
C1188 VDD.n766 VSS 0.03901f
C1189 VDD.n767 VSS 1.84468f
C1190 VDD.n768 VSS 0.02543f
C1191 VDD.n769 VSS 0.03274f
C1192 VDD.n770 VSS 0.01643f
C1193 VDD.n771 VSS 0.51335f
C1194 VDD.n772 VSS 0.64001f
C1195 VDD.t93 VSS 3.6106f
C1196 VDD.n775 VSS 0.70451f
C1197 VDD.n776 VSS 0.12799f
C1198 VDD.n777 VSS 1.98574f
C1199 VDD.n778 VSS 1.22812f
C1200 VDD.n779 VSS 0.7213f
C1201 VDD.n780 VSS 0.12799f
C1202 VDD.n781 VSS 1.98574f
C1203 VDD.n782 VSS 5.03032f
C1204 VDD.n783 VSS 3.155f
C1205 VDD.n784 VSS 0.22491f
C1206 VDD.n785 VSS 0.04978f
C1207 VDD.n786 VSS 0.03896f
C1208 VDD.n787 VSS 4.45309f
C1209 VDD.n788 VSS 3.74428f
C1210 VDD.n789 VSS 4.38277f
C1211 VDD.n790 VSS 4.23598f
C1212 VDD.n791 VSS 1.23966f
C1213 VDD.n793 VSS 0.03228f
C1214 VDD.n795 VSS 0.03228f
C1215 VDD.n797 VSS 0.03228f
C1216 VDD.n799 VSS 0.03228f
C1217 VDD.n801 VSS 0.03228f
C1218 VDD.n803 VSS 0.03228f
C1219 VDD.n805 VSS 0.03228f
C1220 VDD.n807 VSS 0.03228f
C1221 VDD.n809 VSS 0.03228f
C1222 VDD.n811 VSS 0.03228f
C1223 VDD.n813 VSS 0.03228f
C1224 VDD.n815 VSS 0.03228f
C1225 VDD.n817 VSS 0.03228f
C1226 VDD.n819 VSS 0.03228f
C1227 VDD.n821 VSS 0.03228f
C1228 VDD.n823 VSS 0.03228f
C1229 VDD.n825 VSS 0.03228f
C1230 VDD.n827 VSS 0.03228f
C1231 VDD.n829 VSS 0.03228f
C1232 VDD.n831 VSS 0.03228f
C1233 VDD.n833 VSS 0.03228f
C1234 VDD.n834 VSS 19.6637f
C1235 VDD.n835 VSS 0.06612f
C1236 VDD.n836 VSS 3.80403f
C1237 VDD.n837 VSS 27.1004f
C1238 VDD.n861 VSS 0.24517f
C1239 VDD.n863 VSS 12.0418f
C1240 VDD.n864 VSS 0.13967f
C1241 VDD.n865 VSS 0.33809f
C1242 VDD.n866 VSS 1.53999f
C1243 VDD.n867 VSS 0.02472f
C1244 VDD.n868 VSS 0.04103f
C1245 VDD.n869 VSS 0.03943f
C1246 VDD.n870 VSS 0.03943f
C1247 VDD.n871 VSS 0.02543f
C1248 VDD.n872 VSS 0.03901f
C1249 VDD.t114 VSS 3.28602f
C1250 VDD.n873 VSS 0.05256f
C1251 VDD.n874 VSS 0.03943f
C1252 VDD.n875 VSS 0.03397f
C1253 VDD.n876 VSS 0.02519f
C1254 VDD.n877 VSS 0.02502f
C1255 VDD.n878 VSS 0.03901f
C1256 VDD.n879 VSS 0.03943f
C1257 VDD.n880 VSS 0.01645f
C1258 VDD.n881 VSS 0.03901f
C1259 VDD.n882 VSS 0.03943f
C1260 VDD.n883 VSS 0.02629f
C1261 VDD.n884 VSS 0.01657f
C1262 VDD.n885 VSS 0.02519f
C1263 VDD.n886 VSS 0.04984f
C1264 VDD.n887 VSS 0.05256f
C1265 VDD.n888 VSS 0.03389f
C1266 VDD.n889 VSS 0.02502f
C1267 VDD.n890 VSS 0.02629f
C1268 VDD.n891 VSS 0.01657f
C1269 VDD.n892 VSS 0.02519f
C1270 VDD.n893 VSS 0.01645f
C1271 VDD.n894 VSS 0.02543f
C1272 VDD.n895 VSS 1.84468f
C1273 VDD.n896 VSS 0.02543f
C1274 VDD.n897 VSS 0.03943f
C1275 VDD.n898 VSS 0.02629f
C1276 VDD.n899 VSS 0.01657f
C1277 VDD.n900 VSS 0.03286f
C1278 VDD.n901 VSS 0.04103f
C1279 VDD.n902 VSS 0.05f
C1280 VDD.n903 VSS 0.03901f
C1281 VDD.n904 VSS 1.84468f
C1282 VDD.n905 VSS 0.02543f
C1283 VDD.n906 VSS 0.03274f
C1284 VDD.n907 VSS 0.11794f
C1285 V_w1.t0 VSS 1.95745f
C1286 V_shift.t0 VSS 1.64323f
C1287 V_shift.n0 VSS 2.52503f
C1288 V_out_perceptron.t0 VSS 1.64323f
C1289 V_out_perceptron.n0 VSS 2.4448f
C1290 I_x1.t0 VSS 0.3464f
C1291 I_x1.n0 VSS 6.23813f
C1292 V_b.t0 VSS 1.95745f
C1293 I_x2.t0 VSS 1.9582f
C1294 V_w2.t0 VSS 1.95825f
.ends perceptron_pex_rc
