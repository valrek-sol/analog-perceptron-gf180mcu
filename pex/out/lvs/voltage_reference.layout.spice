* NGSPICE file created from voltage_reference.ext - technology: gf180mcuD

.subckt voltage_reference VSS VDD v_1_65 v_1_25 v_1_15
X0 a_15839_13410# VSS VSS VSS nfet_03v3 ad=1.3p pd=5.52u as=3.05p ps=11.22u w=5u l=1u
X1 VDD a_22665_4323# a_23673_4323# VDD pfet_03v3 ad=2.6p pd=10.52u as=2.6p ps=10.52u w=10u l=2u
X2 VDD a_23673_4323# v_1_25 VSS nfet_03v3 ad=2.6p pd=10.52u as=2.6p ps=10.52u w=10u l=1u
X3 a_8213_3015# a_8317_2883# VSS VSS nfet_03v3 ad=0.65p pd=3.02u as=0.65p ps=3.02u w=2.5u l=2u
X4 v_1_65 a_3570_3125# VDD VSS nfet_03v3 ad=2.6p pd=10.52u as=2.6p ps=10.52u w=10u l=1u
X5 VDD a_20295_2963# VSS ppolyf_u_1k r_width=3u r_length=30u
X6 a_8213_3015# a_8317_4191# a_8213_4323# VSS nfet_03v3 ad=1.3p pd=5.52u as=1.3p ps=5.52u w=5u l=2u
X7 a_18591_16275# a_19443_11547# VSS ppolyf_u_1k r_width=3u r_length=23u
X8 a_11251_9091# VSS VSS ppolyf_u_1k r_width=3u r_length=30u
X9 VSS VSS a_8213_3015# VSS nfet_03v3 ad=1.525p pd=6.22u as=0.65p ps=3.02u w=2.5u l=2u
X10 v_1_15 v_1_15 a_15839_11832# VDD pfet_03v3 ad=2.6p pd=10.52u as=2.6p ps=10.52u w=10u l=1u
X11 a_3570_3125# v_1_65 a_8213_3015# VSS nfet_03v3 ad=1.3p pd=5.52u as=1.3p ps=5.52u w=5u l=2u
X12 v_1_25 a_23673_4323# VDD VSS nfet_03v3 ad=2.6p pd=10.52u as=2.6p ps=10.52u w=10u l=1u
X13 a_11251_16275# a_12103_9547# VSS ppolyf_u_1k r_width=3u r_length=33u
X14 v_1_65 a_3570_3125# VDD VSS nfet_03v3 ad=2.6p pd=10.52u as=2.6p ps=10.52u w=10u l=1u
X15 VSS VSS a_8213_4323# VSS nfet_03v3 ad=3.05p pd=11.22u as=1.3p ps=5.52u w=5u l=2u
X16 VSS a_8317_2883# a_8213_3015# VSS nfet_03v3 ad=0.65p pd=3.02u as=0.65p ps=3.02u w=2.5u l=2u
X17 a_22665_4323# VDD VDD VDD pfet_03v3 ad=2.6p pd=10.52u as=6.5p ps=21.3u w=10u l=2u
X18 a_8317_2883# VSS VSS VSS nfet_03v3 ad=1.3p pd=5.52u as=3.05p ps=11.22u w=5u l=1u
X19 VDD VDD a_22665_4323# VDD pfet_03v3 ad=6.5p pd=21.3u as=2.6p ps=10.52u w=10u l=2u
X20 a_15943_13274# a_16625_4972# VSS ppolyf_u_1k r_width=3u r_length=10u
X21 a_12955_16275# a_12103_9547# VSS ppolyf_u_1k r_width=3u r_length=33u
X22 a_8213_3015# v_1_65 a_3570_3125# VSS nfet_03v3 ad=1.3p pd=5.52u as=1.3p ps=5.52u w=5u l=2u
X23 VDD a_23673_4323# v_1_25 VSS nfet_03v3 ad=2.6p pd=10.52u as=2.6p ps=10.52u w=10u l=1u
X24 a_11251_9091# a_12103_2963# VSS ppolyf_u_1k r_width=3u r_length=30u
X25 v_1_65 a_3570_3125# VDD VSS nfet_03v3 ad=2.6p pd=10.52u as=2.6p ps=10.52u w=10u l=1u
X26 VDD VDD a_15839_11832# VDD pfet_03v3 ad=3.25p pd=11.3u as=1.3p ps=5.52u w=5u l=1u
X27 a_8317_2883# a_8317_2883# VSS VSS nfet_03v3 ad=1.3p pd=5.52u as=1.3p ps=5.52u w=5u l=1u
X28 VDD VDD a_14659_9091# VDD pfet_03v3 ad=3.25p pd=11.3u as=1.3p ps=5.52u w=5u l=1u
X29 v_1_25 a_23673_4323# VDD VSS nfet_03v3 ad=2.6p pd=10.52u as=2.6p ps=10.52u w=10u l=1u
X30 a_12955_9091# a_12103_2963# VSS ppolyf_u_1k r_width=3u r_length=30u
X31 a_23673_4323# a_22665_4323# VDD VDD pfet_03v3 ad=2.6p pd=10.52u as=2.6p ps=10.52u w=10u l=2u
X32 VDD a_14659_9091# a_15839_11832# VDD pfet_03v3 ad=1.3p pd=5.52u as=1.3p ps=5.52u w=5u l=1u
X33 a_15839_11832# VDD VDD VDD pfet_03v3 ad=1.3p pd=5.52u as=3.25p ps=11.3u w=5u l=1u
X34 a_12955_16275# a_8317_4191# VSS ppolyf_u_1k r_width=3u r_length=33u
X35 VDD a_3570_3125# v_1_65 VSS nfet_03v3 ad=2.6p pd=10.52u as=2.6p ps=10.52u w=10u l=1u
X36 VSS a_15839_13410# a_15839_13410# VSS nfet_03v3 ad=1.3p pd=5.52u as=1.3p ps=5.52u w=5u l=1u
X37 VDD VDD a_15839_13410# VDD pfet_03v3 ad=6.5p pd=21.3u as=2.6p ps=10.52u w=10u l=1u
X38 a_8213_4323# a_8213_4323# VDD VDD pfet_03v3 ad=2.6p pd=10.52u as=2.6p ps=10.52u w=10u l=2u
X39 VDD a_23673_4323# v_1_25 VSS nfet_03v3 ad=2.6p pd=10.52u as=2.6p ps=10.52u w=10u l=1u
X40 v_1_65 a_3570_3125# VDD VSS nfet_03v3 ad=2.6p pd=10.52u as=2.6p ps=10.52u w=10u l=1u
X41 a_15839_11832# v_1_15 v_1_15 VDD pfet_03v3 ad=2.6p pd=10.52u as=2.6p ps=10.52u w=10u l=1u
X42 a_8213_4323# VDD VDD VDD pfet_03v3 ad=2.6p pd=10.52u as=6.5p ps=21.3u w=10u l=2u
X43 a_18591_16275# a_15943_13274# VSS ppolyf_u_1k r_width=3u r_length=23u
X44 a_15839_13410# VDD VDD VDD pfet_03v3 ad=2.6p pd=10.52u as=6.5p ps=21.3u w=10u l=1u
X45 a_22665_4323# a_22665_4323# VDD VDD pfet_03v3 ad=2.6p pd=10.52u as=2.6p ps=10.52u w=10u l=2u
X46 a_12955_9091# a_13807_2963# VSS ppolyf_u_1k r_width=3u r_length=30u
X47 a_15773_9100# a_8317_4191# VSS ppolyf_u_1k r_width=3u r_length=20u
X48 v_1_25 a_23673_4323# VDD VSS nfet_03v3 ad=2.6p pd=10.52u as=2.6p ps=10.52u w=10u l=1u
X49 VDD a_23673_4323# v_1_25 VSS nfet_03v3 ad=2.6p pd=10.52u as=2.6p ps=10.52u w=10u l=1u
X50 VDD a_3570_3125# v_1_65 VSS nfet_03v3 ad=2.6p pd=10.52u as=2.6p ps=10.52u w=10u l=1u
X51 VSS a_8317_2883# a_22665_3015# VSS nfet_03v3 ad=0.65p pd=3.02u as=0.65p ps=3.02u w=2.5u l=2u
X52 VDD a_8213_4323# a_8213_4323# VDD pfet_03v3 ad=2.6p pd=10.52u as=2.6p ps=10.52u w=10u l=2u
X53 VSS VSS a_8317_2883# VSS nfet_03v3 ad=3.05p pd=11.22u as=1.3p ps=5.52u w=5u l=1u
X54 a_3570_3125# a_8213_4323# VDD VDD pfet_03v3 ad=2.6p pd=10.52u as=2.6p ps=10.52u w=10u l=2u
X55 VDD a_14659_9091# a_14659_9091# VDD pfet_03v3 ad=1.3p pd=5.52u as=1.3p ps=5.52u w=5u l=1u
X56 VDD a_23673_4323# v_1_25 VSS nfet_03v3 ad=2.6p pd=10.52u as=2.6p ps=10.52u w=10u l=1u
X57 a_22665_3015# a_16625_4972# a_22665_4323# VSS nfet_03v3 ad=1.3p pd=5.52u as=1.3p ps=5.52u w=5u l=2u
X58 a_17739_9091# a_18591_2963# VSS ppolyf_u_1k r_width=3u r_length=30u
X59 VDD VDD a_8213_4323# VDD pfet_03v3 ad=6.5p pd=21.3u as=2.6p ps=10.52u w=10u l=2u
X60 v_1_65 a_3570_3125# VDD VSS nfet_03v3 ad=2.6p pd=10.52u as=2.6p ps=10.52u w=10u l=1u
X61 a_20295_16275# a_21147_11547# VSS ppolyf_u_1k r_width=3u r_length=23u
X62 a_15839_13410# a_15839_13410# VSS VSS nfet_03v3 ad=1.3p pd=5.52u as=1.3p ps=5.52u w=5u l=1u
X63 VSS VSS VDD VSS nfet_03v3 ad=6.1p pd=21.22u as=2.6p ps=10.52u w=10u l=1u
X64 v_1_25 VSS VSS ppolyf_u_1k r_width=3u r_length=20u
X65 a_15773_9100# a_16625_4972# VSS ppolyf_u_1k r_width=3u r_length=20u
X66 VDD a_14659_9091# a_15839_11832# VDD pfet_03v3 ad=1.3p pd=5.52u as=1.3p ps=5.52u w=5u l=1u
X67 VDD a_10399_9547# VSS ppolyf_u_1k r_width=3u r_length=33u
X68 VSS a_8317_2883# a_22665_3015# VSS nfet_03v3 ad=0.65p pd=3.02u as=0.65p ps=3.02u w=2.5u l=2u
X69 VDD a_8213_4323# a_3570_3125# VDD pfet_03v3 ad=2.6p pd=10.52u as=2.6p ps=10.52u w=10u l=2u
X70 v_1_25 a_23673_4323# VDD VSS nfet_03v3 ad=2.6p pd=10.52u as=2.6p ps=10.52u w=10u l=1u
X71 VSS v_1_65 VSS ppolyf_u_1k r_width=3u r_length=20u
X72 a_22665_3015# v_1_25 a_23673_4323# VSS nfet_03v3 ad=1.3p pd=5.52u as=1.3p ps=5.52u w=5u l=2u
X73 a_19443_9091# a_18591_2963# VSS ppolyf_u_1k r_width=3u r_length=30u
X74 a_15839_11832# a_15943_13274# a_15839_13410# VDD pfet_03v3 ad=2.6p pd=10.52u as=2.6p ps=10.52u w=10u l=1u
X75 v_1_25 a_23673_4323# VDD VSS nfet_03v3 ad=2.6p pd=10.52u as=2.6p ps=10.52u w=10u l=1u
X76 a_22665_3015# VSS VSS VSS nfet_03v3 ad=0.65p pd=3.02u as=1.525p ps=6.22u w=2.5u l=2u
X77 VSS VSS a_22665_3015# VSS nfet_03v3 ad=1.525p pd=6.22u as=0.65p ps=3.02u w=2.5u l=2u
X78 v_1_15 a_15839_13410# VSS VSS nfet_03v3 ad=1.3p pd=5.52u as=1.3p ps=5.52u w=5u l=1u
X79 VSS a_8317_2883# a_8317_2883# VSS nfet_03v3 ad=1.3p pd=5.52u as=1.3p ps=5.52u w=5u l=1u
X80 VDD VSS VSS VSS nfet_03v3 ad=2.6p pd=10.52u as=6.1p ps=21.22u w=10u l=1u
X81 VSS VSS a_22665_4323# VSS nfet_03v3 ad=3.05p pd=11.22u as=1.3p ps=5.52u w=5u l=2u
X82 a_22665_4323# VSS VSS VSS nfet_03v3 ad=1.3p pd=5.52u as=3.05p ps=11.22u w=5u l=2u
X83 VDD a_3570_3125# v_1_65 VSS nfet_03v3 ad=2.6p pd=10.52u as=2.6p ps=10.52u w=10u l=1u
X84 a_14659_9091# a_13807_2963# VSS ppolyf_u_1k r_width=3u r_length=30u
X85 a_15839_11832# a_14659_9091# VDD VDD pfet_03v3 ad=1.3p pd=5.52u as=1.3p ps=5.52u w=5u l=1u
X86 VSS VSS VDD VSS nfet_03v3 ad=6.1p pd=21.22u as=2.6p ps=10.52u w=10u l=1u
X87 a_22665_3015# a_8317_2883# VSS VSS nfet_03v3 ad=0.65p pd=3.02u as=0.65p ps=3.02u w=2.5u l=2u
X88 a_20295_16275# a_19443_11547# VSS ppolyf_u_1k r_width=3u r_length=23u
X89 a_17739_9091# a_8317_2883# VSS ppolyf_u_1k r_width=3u r_length=30u
X90 VDD a_3570_3125# v_1_65 VSS nfet_03v3 ad=2.6p pd=10.52u as=2.6p ps=10.52u w=10u l=1u
X91 a_23673_4323# v_1_25 a_22665_3015# VSS nfet_03v3 ad=1.3p pd=5.52u as=1.3p ps=5.52u w=5u l=2u
X92 a_15839_13410# a_15943_13274# a_15839_11832# VDD pfet_03v3 ad=2.6p pd=10.52u as=2.6p ps=10.52u w=10u l=1u
X93 a_8213_3015# a_8317_2883# VSS VSS nfet_03v3 ad=0.65p pd=3.02u as=0.65p ps=3.02u w=2.5u l=2u
X94 a_14659_9091# VDD VDD VDD pfet_03v3 ad=1.3p pd=5.52u as=3.25p ps=11.3u w=5u l=1u
X95 VDD a_22665_4323# a_22665_4323# VDD pfet_03v3 ad=2.6p pd=10.52u as=2.6p ps=10.52u w=10u l=2u
X96 a_8213_3015# VSS VSS VSS nfet_03v3 ad=0.65p pd=3.02u as=1.525p ps=6.22u w=2.5u l=2u
X97 a_19443_9091# a_20295_2963# VSS ppolyf_u_1k r_width=3u r_length=30u
X98 a_22665_3015# a_8317_2883# VSS VSS nfet_03v3 ad=0.65p pd=3.02u as=0.65p ps=3.02u w=2.5u l=2u
X99 a_8213_4323# a_8317_4191# a_8213_3015# VSS nfet_03v3 ad=1.3p pd=5.52u as=1.3p ps=5.52u w=5u l=2u
X100 VSS VSS a_15839_13410# VSS nfet_03v3 ad=3.05p pd=11.22u as=1.3p ps=5.52u w=5u l=1u
X101 VDD a_3570_3125# v_1_65 VSS nfet_03v3 ad=2.6p pd=10.52u as=2.6p ps=10.52u w=10u l=1u
X102 a_8213_4323# VSS VSS VSS nfet_03v3 ad=1.3p pd=5.52u as=3.05p ps=11.22u w=5u l=2u
X103 a_11251_16275# a_10399_9547# VSS ppolyf_u_1k r_width=3u r_length=33u
X104 VSS a_21147_11547# VSS ppolyf_u_1k r_width=3u r_length=23u
X105 a_15839_11832# a_14659_9091# VDD VDD pfet_03v3 ad=1.3p pd=5.52u as=1.3p ps=5.52u w=5u l=1u
X106 a_22665_4323# a_16625_4972# a_22665_3015# VSS nfet_03v3 ad=1.3p pd=5.52u as=1.3p ps=5.52u w=5u l=2u
X107 a_14659_9091# a_14659_9091# VDD VDD pfet_03v3 ad=1.3p pd=5.52u as=1.3p ps=5.52u w=5u l=1u
X108 VSS a_15839_13410# v_1_15 VSS nfet_03v3 ad=1.3p pd=5.52u as=1.3p ps=5.52u w=5u l=1u
X109 VSS a_8317_2883# a_8213_3015# VSS nfet_03v3 ad=0.65p pd=3.02u as=0.65p ps=3.02u w=2.5u l=2u
X110 VDD VSS VSS VSS nfet_03v3 ad=2.6p pd=10.52u as=6.1p ps=21.22u w=10u l=1u
.ends
