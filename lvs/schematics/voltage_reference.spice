** sch_path: /foss/designs/analog-perceptron-gf180mcu/schematics/voltage_reference.sch
.subckt voltage_reference VDD v_1_65 v_1_25 v_1_15 v_0_7 VSS
*.PININFO VDD:B VSS:B v_1_65:O v_1_15:O v_0_7:O v_1_25:O
XR1 V_I_1_65 VDD VSS ppolyf_u_1k r_width=3e-6 r_length=165e-6
XR2 V_I_1_25 V_I_1_65 VSS ppolyf_u_1k r_width=3e-6 r_length=40e-6
XR3 V_I_1_15 V_I_1_25 VSS ppolyf_u_1k r_width=3e-6 r_length=10e-6
XR4 V_I_0_7 V_I_1_15 VSS ppolyf_u_1k r_width=3e-6 r_length=45e-6
XR5 VSS V_I_0_7 VSS ppolyf_u_1k r_width=3e-6 r_length=70e-6
M11 net2 V_pbias VDD VDD pfet_03v3 L=1u W=20u nf=1
M12 net1 V_I_1_15 net2 VDD pfet_03v3 L=1u W=20u nf=1
M13 v_1_15 v_1_15 net2 VDD pfet_03v3 L=1u W=20u nf=1
M14 net1 net1 VSS VSS nfet_03v3 L=1u W=10u nf=1
M15 v_1_15 net1 VSS VSS nfet_03v3 L=1u W=10u nf=1
M16 net4 V_pbias VDD VDD pfet_03v3 L=1u W=20u nf=1
M17 net3 V_I_0_7 net4 VDD pfet_03v3 L=1u W=20u nf=1
M18 v_0_7 v_0_7 net4 VDD pfet_03v3 L=1u W=20u nf=1
M19 net3 net3 VSS VSS nfet_03v3 L=1u W=10u nf=1
M20 v_0_7 net3 VSS VSS nfet_03v3 L=1u W=10u nf=1
M21 VDD net10 v_1_25 VSS nfet_03v3 L=1u W=100u nf=1
XR6 VSS v_1_25 VSS ppolyf_u_1k r_width=3e-6 r_length=30e-6
M22 V_pbias V_pbias VDD VDD pfet_03v3 L=1u W=10u nf=1
XR7 VSS V_pbias VSS ppolyf_u_1k r_width=3e-6 r_length=150e-6
M1 net6 V_I_1_65 net5 VSS nfet_03v3 L=2u W=10u nf=1
M2 net7 v_1_65 net5 VSS nfet_03v3 L=2u W=10u nf=1
M3 net5 V_nbias VSS VSS nfet_03v3 L=2u W=10u nf=1
M4 net6 net6 VDD VDD pfet_03v3 L=2u W=20u nf=1
M5 net7 net6 VDD VDD pfet_03v3 L=2u W=20u nf=1
M23 V_nbias V_nbias VSS VSS nfet_03v3 L=1u W=10u nf=1
XR8 V_nbias VDD VSS ppolyf_u_1k r_width=3e-6 r_length=150e-6
M6 net9 V_I_1_25 net8 VSS nfet_03v3 L=2u W=10u nf=1
M7 net10 v_1_25 net8 VSS nfet_03v3 L=2u W=10u nf=1
M8 net8 V_nbias VSS VSS nfet_03v3 L=2u W=10u nf=1
M9 net9 net9 VDD VDD pfet_03v3 L=2u W=20u nf=1
M10 net10 net9 VDD VDD pfet_03v3 L=2u W=20u nf=1
M24 VDD net7 v_1_65 VSS nfet_03v3 L=1u W=100u nf=1
XR9 VSS v_1_65 VSS ppolyf_u_1k r_width=3e-6 r_length=30e-6
.ends
