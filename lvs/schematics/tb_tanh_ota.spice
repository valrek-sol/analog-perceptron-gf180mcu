** sch_path: /foss/designs/analog-perceptron-gf180mcu/schematics/tb_tanh_ota.sch
.subckt tb_tanh_ota

x1 net3 net2 V_out net5 net1 net4 0 tanh_ota
V_REF net2 0 1.65
V_SUPPLY net3 0 3.3
V_BIAS net4 0 0.7
V_IN_N net1 0 2.3
V_IN_P net5 0 2.3
**** begin user architecture code

.include /foss/pdks/gf180mcuD/libs.tech/ngspice/design.ngspice
.lib /foss/pdks/gf180mcuD/libs.tech/ngspice/sm141064.ngspice typical
.lib /foss/pdks/gf180mcuD/libs.tech/ngspice/sm141064.ngspice res_typical
* .lib /foss/pdks/gf180mcuD/libs.tech/ngspice/sm141064.ngspice res_statistical

.control
  op
  echo "--- tanh OTA x1: transistor op points ---"
  print @m.x1.xm1.m0[vgs] @m.x1.xm1.m0[vth] @m.x1.xm1.m0[vdsat] @m.x1.xm1.m0[id] @m.x1.xm1.m0[gm] @m.x1.xm1.m0[gds]
  print @m.x1.xm2.m0[vgs] @m.x1.xm2.m0[vth] @m.x1.xm2.m0[vdsat] @m.x1.xm2.m0[id] @m.x1.xm2.m0[gm] @m.x1.xm2.m0[gds]
  print @m.x1.xm3.m0[vgs] @m.x1.xm3.m0[vth] @m.x1.xm3.m0[vdsat] @m.x1.xm3.m0[id] @m.x1.xm3.m0[gm] @m.x1.xm3.m0[gds]
  print @m.x1.xm4.m0[vgs] @m.x1.xm4.m0[vth] @m.x1.xm4.m0[vdsat] @m.x1.xm4.m0[id] @m.x1.xm4.m0[gm] @m.x1.xm4.m0[gds]
  print @m.x1.xm5.m0[vgs] @m.x1.xm5.m0[vth] @m.x1.xm5.m0[vdsat] @m.x1.xm5.m0[id] @m.x1.xm5.m0[gm] @m.x1.xm5.m0[gds]
  echo "--- tanh OTA x1: reference resistor ---"
  print @r.x1.xr1.rt1[resistance] @r.x1.xr1.rt2[resistance]
  dc V_IN_P 2.1 2.5 0.002
  let V_out = v(V_out)
  plot V_out title "tanh OTA: Saturating Transfer Characteristic"
  wrdata /foss/designs/analog-perceptron-gf180mcu/plots/tanh_ota_sweep.txt V_out
  * === OP-SWEEP DIAGNOSTIC: all 5 devices' headroom across full input range ===
  save all @m.x1.xm1.m0[vgs] @m.x1.xm1.m0[vth] @m.x1.xm1.m0[vdsat] @m.x1.xm1.m0[id] @m.x1.xm1.m0[gm] @m.x1.xm1.m0[gds] @m.x1.xm2.m0[vgs] @m.x1.xm2.m0[vth] @m.x1.xm2.m0[vdsat] @m.x1.xm2.m0[id] @m.x1.xm2.m0[gm] @m.x1.xm2.m0[gds] @m.x1.xm3.m0[vgs] @m.x1.xm3.m0[vth] @m.x1.xm3.m0[vdsat] @m.x1.xm3.m0[id] @m.x1.xm3.m0[gm] @m.x1.xm3.m0[gds] @m.x1.xm4.m0[vgs] @m.x1.xm4.m0[vth] @m.x1.xm4.m0[vdsat] @m.x1.xm4.m0[id] @m.x1.xm4.m0[gm] @m.x1.xm4.m0[gds] @m.x1.xm5.m0[vgs] @m.x1.xm5.m0[vth] @m.x1.xm5.m0[vdsat] @m.x1.xm5.m0[id] @m.x1.xm5.m0[gm] @m.x1.xm5.m0[gds]
  dc V_IN_P 2.1 2.5 0.002
  wrdata /foss/designs/analog-perceptron-gf180mcu/plots/opsweep_tanh_ota.txt v(V_out) @m.x1.xm1.m0[vgs] @m.x1.xm1.m0[vth] @m.x1.xm1.m0[vdsat] @m.x1.xm1.m0[id] @m.x1.xm1.m0[gm] @m.x1.xm1.m0[gds] @m.x1.xm2.m0[vgs] @m.x1.xm2.m0[vth] @m.x1.xm2.m0[vdsat] @m.x1.xm2.m0[id] @m.x1.xm2.m0[gm] @m.x1.xm2.m0[gds] @m.x1.xm3.m0[vgs] @m.x1.xm3.m0[vth] @m.x1.xm3.m0[vdsat] @m.x1.xm3.m0[id] @m.x1.xm3.m0[gm] @m.x1.xm3.m0[gds] @m.x1.xm4.m0[vgs] @m.x1.xm4.m0[vth] @m.x1.xm4.m0[vdsat] @m.x1.xm4.m0[id] @m.x1.xm4.m0[gm] @m.x1.xm4.m0[gds] @m.x1.xm5.m0[vgs] @m.x1.xm5.m0[vth] @m.x1.xm5.m0[vdsat] @m.x1.xm5.m0[id] @m.x1.xm5.m0[gm] @m.x1.xm5.m0[gds]
.endc

**** end user architecture code
.ends

* expanding   symbol:  analog-perceptron-gf180mcu/schematics/tanh_ota.sym # of pins=7
** sym_path: /foss/designs/analog-perceptron-gf180mcu/schematics/tanh_ota.sym
** sch_path: /foss/designs/analog-perceptron-gf180mcu/schematics/tanh_ota.sch
.subckt tanh_ota VDD V_ref V_out V_in_p V_in_n V_bias VSS
*.PININFO VDD:B VSS:B V_in_p:I V_in_n:I V_bias:I V_out:O V_ref:B
M1 net2 V_in_p net1 VSS nfet_03v3 L=0.5u W=10u nf=1
M2 V_out V_in_n net1 VSS nfet_03v3 L=0.5u W=10u nf=1
M3 net1 V_bias VSS VSS nfet_03v3 L=0.5u W=10u nf=1
M4 net2 net2 VDD VDD pfet_03v3 L=0.5u W=20u nf=1
M5 V_out net2 VDD VDD pfet_03v3 L=0.5u W=20u nf=1
XR1 V_out V_ref VSS ppolyf_u_1k r_width=3e-6 r_length=12.4e-6 m=6
.ends
