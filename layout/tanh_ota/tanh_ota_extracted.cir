* Extracted by KLayout with GF180MCU LVS runset on : 14/08/2026 11:53

.SUBCKT tanh_ota V_ref VDD V_out V_bias V_in_n V_in_p VSS
M$1 \$5 V_in_p \$2 VSS nfet_03v3 L=0.5U W=10U AS=4.35P AD=3.3P PS=16.74U
+ PD=11.32U
M$3 V_out V_in_n \$2 VSS nfet_03v3 L=0.5U W=10U AS=3.3P AD=4.35P PS=11.32U
+ PD=16.74U
M$5 \$2 V_bias VSS VSS nfet_03v3 L=0.5U W=10U AS=4.35P AD=4.35P PS=16.74U
+ PD=16.74U
R$8 V_out V_ref VSS 24800 ppolyf_u_1k L=74.4U W=3U
M$13 V_out \$5 VDD VDD pfet_03v3 L=0.5U W=20U AS=9.1P AD=9.1P PS=31.82U
+ PD=31.82U
M$15 \$5 \$5 VDD VDD pfet_03v3 L=0.5U W=20U AS=9.1P AD=9.1P PS=31.82U PD=31.82U
.ENDS tanh_ota
