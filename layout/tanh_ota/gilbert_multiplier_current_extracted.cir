* Extracted by KLayout with GF180MCU LVS runset on : 14/08/2026 11:52

.SUBCKT gilbert_multiplier_current
X$1 \$5 \$1 VSS ppolyf_u_high_Rs_resistor
X$2 \$6 \$1 VSS ppolyf_u_high_Rs_resistor
X$3 \$6 \$2 VSS ppolyf_u_high_Rs_resistor
X$4 \$4 \$2 VSS ppolyf_u_high_Rs_resistor
X$5 VSS VSS \$4 V_tail V_tail nfet$4
X$6 \$4 \$4 \$18 \$4 \$18 V_x_p V_x_p V_x_p V_x_p nfet
X$7 VSS VSS \$5 V_tail V_tail nfet$4
X$8 \$5 \$5 \$17 \$5 \$17 V_x_n V_x_n V_x_n V_x_n nfet
X$9 \$17 \$17 I_o_n \$17 I_o_n V_w_n V_w_n V_w_n V_w_n nfet
X$10 \$17 \$17 I_o_p \$17 I_o_p V_w_p V_w_p V_w_p V_w_p nfet
X$11 \$18 \$18 I_o_p \$18 I_o_p V_w_n V_w_n V_w_n V_w_n nfet
X$12 \$18 \$18 I_o_n \$18 I_o_n V_w_p V_w_p V_w_p V_w_p nfet
M$1 I_o_n V_w_p \$18 VSS nfet_03v3 L=0.5U W=2.5U AS=1.525P AD=0.65P PS=6.22U
+ PD=3.02U
M$2 \$18 V_w_p I_o_n VSS nfet_03v3 L=0.5U W=2.5U AS=0.65P AD=0.65P PS=3.02U
+ PD=3.02U
M$3 I_o_n V_w_p \$18 VSS nfet_03v3 L=0.5U W=2.5U AS=0.65P AD=0.65P PS=3.02U
+ PD=3.02U
M$4 \$18 V_w_p I_o_n VSS nfet_03v3 L=0.5U W=2.5U AS=0.65P AD=1P PS=3.02U PD=3.3U
M$5 I_o_p V_w_n \$18 VSS nfet_03v3 L=0.5U W=2.5U AS=1P AD=0.65P PS=3.3U PD=3.02U
M$6 \$18 V_w_n I_o_p VSS nfet_03v3 L=0.5U W=2.5U AS=0.65P AD=0.65P PS=3.02U
+ PD=3.02U
M$7 I_o_p V_w_n \$18 VSS nfet_03v3 L=0.5U W=2.5U AS=0.65P AD=0.65P PS=3.02U
+ PD=3.02U
M$8 \$18 V_w_n I_o_p VSS nfet_03v3 L=0.5U W=2.5U AS=0.65P AD=1.525P PS=3.02U
+ PD=6.22U
M$9 \$18 V_x_p \$4 VSS nfet_03v3 L=0.5U W=2.5U AS=1.525P AD=0.65P PS=6.22U
+ PD=3.02U
M$10 \$4 V_x_p \$18 VSS nfet_03v3 L=0.5U W=2.5U AS=0.65P AD=0.65P PS=3.02U
+ PD=3.02U
M$11 \$18 V_x_p \$4 VSS nfet_03v3 L=0.5U W=2.5U AS=0.65P AD=0.65P PS=3.02U
+ PD=3.02U
M$12 \$4 V_x_p \$18 VSS nfet_03v3 L=0.5U W=2.5U AS=0.65P AD=1.525P PS=3.02U
+ PD=6.22U
M$13 I_o_n V_w_n \$17 VSS nfet_03v3 L=0.5U W=2.5U AS=1.525P AD=0.65P PS=6.22U
+ PD=3.02U
M$14 \$17 V_w_n I_o_n VSS nfet_03v3 L=0.5U W=2.5U AS=0.65P AD=0.65P PS=3.02U
+ PD=3.02U
M$15 I_o_n V_w_n \$17 VSS nfet_03v3 L=0.5U W=2.5U AS=0.65P AD=0.65P PS=3.02U
+ PD=3.02U
M$16 \$17 V_w_n I_o_n VSS nfet_03v3 L=0.5U W=2.5U AS=0.65P AD=1P PS=3.02U
+ PD=3.3U
M$17 I_o_p V_w_p \$17 VSS nfet_03v3 L=0.5U W=2.5U AS=1P AD=0.65P PS=3.3U
+ PD=3.02U
M$18 \$17 V_w_p I_o_p VSS nfet_03v3 L=0.5U W=2.5U AS=0.65P AD=0.65P PS=3.02U
+ PD=3.02U
M$19 I_o_p V_w_p \$17 VSS nfet_03v3 L=0.5U W=2.5U AS=0.65P AD=0.65P PS=3.02U
+ PD=3.02U
M$20 \$17 V_w_p I_o_p VSS nfet_03v3 L=0.5U W=2.5U AS=0.65P AD=1.525P PS=3.02U
+ PD=6.22U
M$21 \$4 V_tail VSS VSS nfet_03v3 L=1U W=2.5U AS=1.525P AD=0.65P PS=6.22U
+ PD=3.02U
M$22 VSS V_tail \$4 VSS nfet_03v3 L=1U W=2.5U AS=0.65P AD=1P PS=3.02U PD=3.3U
M$23 \$5 V_tail VSS VSS nfet_03v3 L=1U W=2.5U AS=1P AD=0.65P PS=3.3U PD=3.02U
M$24 VSS V_tail \$5 VSS nfet_03v3 L=1U W=2.5U AS=0.65P AD=1.525P PS=3.02U
+ PD=6.22U
M$25 \$17 V_x_n \$5 VSS nfet_03v3 L=0.5U W=2.5U AS=1.525P AD=0.65P PS=6.22U
+ PD=3.02U
M$26 \$5 V_x_n \$17 VSS nfet_03v3 L=0.5U W=2.5U AS=0.65P AD=0.65P PS=3.02U
+ PD=3.02U
M$27 \$17 V_x_n \$5 VSS nfet_03v3 L=0.5U W=2.5U AS=0.65P AD=0.65P PS=3.02U
+ PD=3.02U
M$28 \$5 V_x_n \$17 VSS nfet_03v3 L=0.5U W=2.5U AS=0.65P AD=1.525P PS=3.02U
+ PD=6.22U
.ENDS gilbert_multiplier_current

.SUBCKT nfet$4 \$1 \$2 \$3 \$4 \$5
.ENDS nfet$4

.SUBCKT nfet \$1 \$2 \$3 \$4 \$5 \$6 \$7 \$8 \$9
.ENDS nfet

.SUBCKT ppolyf_u_high_Rs_resistor \$1 \$2 \$4
R$1 \$1 \$2 \$4 3850 ppolyf_u_1k L=11.55U W=3U
.ENDS ppolyf_u_high_Rs_resistor
