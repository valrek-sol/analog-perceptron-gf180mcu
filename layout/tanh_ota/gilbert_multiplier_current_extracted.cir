* Extracted by KLayout with GF180MCU LVS runset on : 11/08/2026 22:23

.SUBCKT gilbert_multiplier_current
X$1 \$1 \$1 \$4 \$7 \$7 nfet
X$2 \$1 \$1 \$3 \$7 \$7 nfet
X$3 SUB ppolyf_u_high_Rs_resistor
X$4 SUB ppolyf_u_high_Rs_resistor
X$5 SUB ppolyf_u_high_Rs_resistor
X$6 SUB ppolyf_u_high_Rs_resistor
M$1 \$4 \$7 \$1 SUB nfet_03v3 L=0.28U W=2.5U AS=1.525P AD=0.65P PS=6.22U
+ PD=3.02U
M$2 \$1 \$7 \$4 SUB nfet_03v3 L=0.28U W=2.5U AS=0.65P AD=1P PS=3.02U PD=3.3U
M$3 \$3 \$7 \$1 SUB nfet_03v3 L=0.28U W=2.5U AS=1P AD=0.65P PS=3.3U PD=3.02U
M$4 \$1 \$7 \$3 SUB nfet_03v3 L=0.28U W=2.5U AS=0.65P AD=1.525P PS=3.02U
+ PD=6.22U
.ENDS gilbert_multiplier_current

.SUBCKT ppolyf_u_high_Rs_resistor \$4
R$1 \$1 \$2 \$4 3850 ppolyf_u_1k L=11.55U W=3U
.ENDS ppolyf_u_high_Rs_resistor

.SUBCKT nfet \$1 \$2 \$3 \$4 \$5
.ENDS nfet
