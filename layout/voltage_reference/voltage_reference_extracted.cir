* Extracted by KLayout with GF180MCU LVS runset on : 01/09/2026 15:10

.SUBCKT voltage_reference VDD v_1_65 v_1_25 v_1_15 VSS
M$1 \$16 VDD VDD VDD pfet_03v3 L=2U W=20U AS=9.1P AD=9.1P PS=31.82U PD=31.82U
M$2 VDD \$16 \$16 VDD pfet_03v3 L=2U W=20U AS=5.2P AD=5.2P PS=21.04U PD=21.04U
M$3 \$17 \$16 VDD VDD pfet_03v3 L=2U W=20U AS=5.2P AD=5.2P PS=21.04U PD=21.04U
M$7 \$18 VDD VDD VDD pfet_03v3 L=2U W=20U AS=9.1P AD=9.1P PS=31.82U PD=31.82U
M$8 VDD \$18 \$18 VDD pfet_03v3 L=2U W=20U AS=5.2P AD=5.2P PS=21.04U PD=21.04U
M$9 \$19 \$18 VDD VDD pfet_03v3 L=2U W=20U AS=5.2P AD=5.2P PS=21.04U PD=21.04U
M$13 \$36 VDD VDD VDD pfet_03v3 L=1U W=20U AS=9.1P AD=9.1P PS=31.82U PD=31.82U
M$14 \$37 \$23 \$36 VDD pfet_03v3 L=1U W=20U AS=5.2P AD=5.2P PS=21.04U PD=21.04U
M$15 v_1_15 v_1_15 \$37 VDD pfet_03v3 L=1U W=20U AS=5.2P AD=5.2P PS=21.04U
+ PD=21.04U
M$19 \$18 VSS VSS VSS nfet_03v3 L=2U W=10U AS=4.35P AD=4.35P PS=16.74U PD=16.74U
M$20 \$11 \$14 \$18 VSS nfet_03v3 L=2U W=10U AS=2.6P AD=2.6P PS=11.04U PD=11.04U
M$21 \$19 v_1_25 \$11 VSS nfet_03v3 L=2U W=10U AS=2.6P AD=2.6P PS=11.04U
+ PD=11.04U
M$25 \$16 VSS VSS VSS nfet_03v3 L=2U W=10U AS=4.35P AD=4.35P PS=16.74U PD=16.74U
M$26 \$10 \$12 \$16 VSS nfet_03v3 L=2U W=10U AS=2.6P AD=2.6P PS=11.04U PD=11.04U
M$27 \$17 v_1_65 \$10 VSS nfet_03v3 L=2U W=10U AS=2.6P AD=2.6P PS=11.04U
+ PD=11.04U
M$31 \$37 VDD VDD VDD pfet_03v3 L=1U W=10U AS=4.55P AD=4.55P PS=16.82U PD=16.82U
M$32 VDD \$21 \$37 VDD pfet_03v3 L=1U W=20U AS=5.2P AD=5.2P PS=22.08U PD=22.08U
R$37 \$23 \$14 VSS 3333.33333333 ppolyf_u_1k L=10U W=3U
R$38 VSS \$23 VSS 38333.3333333 ppolyf_u_1k L=115U W=3U
R$43 VDD \$12 VSS 55000 ppolyf_u_1k L=165U W=3U
M$48 \$36 VSS VSS VSS nfet_03v3 L=1U W=10U AS=4.35P AD=4.35P PS=16.74U PD=16.74U
M$49 VSS \$36 \$36 VSS nfet_03v3 L=1U W=10U AS=2.6P AD=2.6P PS=11.04U PD=11.04U
M$50 v_1_15 \$36 VSS VSS nfet_03v3 L=1U W=10U AS=2.6P AD=2.6P PS=11.04U
+ PD=11.04U
M$54 \$1 VSS VSS VSS nfet_03v3 L=1U W=10U AS=4.35P AD=4.35P PS=16.74U PD=16.74U
M$55 VSS \$1 \$1 VSS nfet_03v3 L=1U W=10U AS=2.6P AD=2.6P PS=11.04U PD=11.04U
R$61 \$21 VSS VSS 50000 ppolyf_u_1k L=150U W=3U
R$63 \$1 VDD VSS 50000 ppolyf_u_1k L=150U W=3U
M$68 \$21 VDD VDD VDD pfet_03v3 L=1U W=10U AS=4.55P AD=4.55P PS=16.82U PD=16.82U
M$69 VDD \$21 \$21 VDD pfet_03v3 L=1U W=10U AS=2.6P AD=2.6P PS=11.04U PD=11.04U
R$72 VSS v_1_65 VSS 6666.66666667 ppolyf_u_1k L=20U W=3U
R$73 \$12 \$14 VSS 13333.3333333 ppolyf_u_1k L=40U W=3U
R$75 VSS v_1_25 VSS 6666.66666667 ppolyf_u_1k L=20U W=3U
M$76 VDD VSS VSS VSS nfet_03v3 L=1U W=40U AS=17.4P AD=17.4P PS=63.48U PD=63.48U
M$77 v_1_65 \$17 VDD VSS nfet_03v3 L=1U W=100U AS=26P AD=26P PS=105.2U PD=105.2U
M$89 v_1_25 \$19 VDD VSS nfet_03v3 L=1U W=100U AS=26P AD=26P PS=105.2U PD=105.2U
M$100 \$10 VSS VSS VSS nfet_03v3 L=2U W=5U AS=2.175P AD=2.175P PS=9.24U PD=9.24U
M$101 VSS \$1 \$10 VSS nfet_03v3 L=2U W=10U AS=2.6P AD=2.6P PS=12.08U PD=12.08U
M$106 \$11 VSS VSS VSS nfet_03v3 L=2U W=5U AS=2.175P AD=2.175P PS=9.24U PD=9.24U
M$107 VSS \$1 \$11 VSS nfet_03v3 L=2U W=10U AS=2.6P AD=2.6P PS=12.08U PD=12.08U
.ENDS voltage_reference
