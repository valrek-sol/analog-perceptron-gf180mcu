* Extracted by KLayout with GF180MCU LVS runset on : 14/08/2026 12:11

.SUBCKT voltage_reference v_1_65 v_1_25 v_1_15 v_0_7 VDD VSS
M$1 \$20 \$20 VSS VSS nfet_03v3 L=1U W=10U AS=4.35P AD=3.3P PS=16.74U PD=11.32U
M$3 v_0_7 \$20 VSS VSS nfet_03v3 L=1U W=10U AS=3.3P AD=4.35P PS=11.32U PD=16.74U
M$5 \$18 \$18 VSS VSS nfet_03v3 L=1U W=10U AS=4.35P AD=3.3P PS=16.74U PD=11.32U
M$7 v_1_15 \$18 VSS VSS nfet_03v3 L=1U W=10U AS=3.3P AD=4.35P PS=11.32U
+ PD=16.74U
M$9 \$74 \$5 \$49 VSS nfet_03v3 L=2U W=10U AS=4.35P AD=3.3P PS=16.74U PD=11.32U
M$11 \$60 v_1_65 \$49 VSS nfet_03v3 L=2U W=10U AS=3.3P AD=4.35P PS=11.32U
+ PD=16.74U
M$13 \$81 \$6 \$50 VSS nfet_03v3 L=2U W=10U AS=4.35P AD=3.3P PS=16.74U PD=11.32U
M$15 \$62 v_1_25 \$50 VSS nfet_03v3 L=2U W=10U AS=3.3P AD=4.35P PS=11.32U
+ PD=16.74U
R$17 \$2 \$3 VSS 15000 ppolyf_u_1k L=45U W=3U
R$18 \$6 \$3 VSS 3333.33333333 ppolyf_u_1k L=10U W=3U
M$19 \$20 \$2 \$42 VDD pfet_03v3 L=1U W=20U AS=7.15P AD=7.15P PS=27.86U
+ PD=27.86U
M$23 \$18 \$3 \$38 VDD pfet_03v3 L=1U W=20U AS=7.15P AD=7.15P PS=27.86U
+ PD=27.86U
M$27 v_1_15 v_1_15 \$38 VDD pfet_03v3 L=1U W=20U AS=7.15P AD=7.15P PS=27.86U
+ PD=27.86U
M$31 v_0_7 v_0_7 \$42 VDD pfet_03v3 L=1U W=20U AS=7.15P AD=7.15P PS=27.86U
+ PD=27.86U
M$35 \$38 \$71 VDD VDD pfet_03v3 L=1U W=20U AS=7.15P AD=7.15P PS=27.86U
+ PD=27.86U
M$39 \$42 \$71 VDD VDD pfet_03v3 L=1U W=20U AS=7.15P AD=7.15P PS=27.86U
+ PD=27.86U
M$43 \$71 \$71 VDD VDD pfet_03v3 L=1U W=10U AS=4.55P AD=4.55P PS=16.82U
+ PD=16.82U
R$45 VDD \$5 VSS 55000 ppolyf_u_1k L=165U W=3U
R$50 VSS \$2 VSS 23333.3333333 ppolyf_u_1k L=70U W=3U
R$51 \$5 \$6 VSS 13333.3333333 ppolyf_u_1k L=40U W=3U
R$56 \$9 VDD VSS 50000 ppolyf_u_1k L=150U W=3U
R$60 VSS \$71 VSS 50000 ppolyf_u_1k L=150U W=3U
M$64 \$9 \$9 VSS VSS nfet_03v3 L=1U W=10U AS=4.35P AD=4.35P PS=16.74U PD=16.74U
R$66 v_1_25 VSS VSS 10000 ppolyf_u_1k L=30U W=3U
R$68 v_1_65 VSS VSS 10000 ppolyf_u_1k L=30U W=3U
M$70 \$49 \$9 VSS VSS nfet_03v3 L=2U W=10U AS=4.35P AD=4.35P PS=16.74U PD=16.74U
M$72 \$50 \$9 VSS VSS nfet_03v3 L=2U W=10U AS=4.35P AD=4.35P PS=16.74U PD=16.74U
M$74 VDD \$60 v_1_65 VSS nfet_03v3 L=1U W=100U AS=29.5P AD=29.5P PS=115.9U
+ PD=115.9U
M$84 VDD \$62 v_1_25 VSS nfet_03v3 L=1U W=100U AS=29.5P AD=29.5P PS=115.9U
+ PD=115.9U
M$94 \$60 \$74 VDD VDD pfet_03v3 L=2U W=20U AS=7.15P AD=7.15P PS=27.86U
+ PD=27.86U
M$98 \$62 \$81 VDD VDD pfet_03v3 L=2U W=20U AS=7.15P AD=7.15P PS=27.86U
+ PD=27.86U
M$102 \$74 \$74 VDD VDD pfet_03v3 L=2U W=20U AS=7.15P AD=7.15P PS=27.86U
+ PD=27.86U
M$106 \$81 \$81 VDD VDD pfet_03v3 L=2U W=20U AS=7.15P AD=7.15P PS=27.86U
+ PD=27.86U
.ENDS voltage_reference
