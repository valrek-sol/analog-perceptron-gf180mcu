* Extracted by KLayout with GF180MCU LVS runset on : 01/09/2026 21:04

.SUBCKT perceptron_core V_w2 I_x2 V_b I_x1 V_out_perceptron VDD V_w1 V_shift VSS
X$1 \$3 \$10 \$6 \$3 V_w2 \$4 \$5 VSS gilbert_multiplier_current
X$2 V_out_perceptron \$3 \$4 \$5 VDD VSS tanh_ota
X$3 \$3 \$10 \$15 \$3 V_w1 \$4 \$5 VSS gilbert_multiplier_current
X$4 VDD \$3 \$10 \$7 VSS voltage_reference
X$5 \$3 \$10 \$7 \$3 V_b \$4 \$5 VSS gilbert_multiplier_current
X$8 \$10 \$6 I_x2 VSS cg_amp_tia
X$9 \$10 \$15 I_x1 VSS cg_amp_tia
R$1 \$4 VDD VSS 2433.33333333 ppolyf_u_1k L=7.3U W=3U
R$2 V_shift \$5 VSS 2433.33333333 ppolyf_u_1k L=7.3U W=3U
.ENDS perceptron_core

.SUBCKT tanh_ota V_out V_ref V_in_n V_in_p VDD VSS
M$1 \$6 VDD VDD VDD pfet_03v3 L=0.5U W=10U AS=4.55P AD=4.55P PS=16.82U PD=16.82U
M$2 VDD \$6 \$6 VDD pfet_03v3 L=0.5U W=20U AS=5.2P AD=5.2P PS=22.08U PD=22.08U
M$3 V_out \$6 VDD VDD pfet_03v3 L=0.5U W=20U AS=5.2P AD=5.2P PS=22.08U PD=22.08U
M$11 \$6 VSS VSS VSS nfet_03v3 L=0.5U W=10U AS=4.35P AD=4.35P PS=16.74U
+ PD=16.74U
M$12 \$5 V_in_p \$6 VSS nfet_03v3 L=0.5U W=10U AS=2.6P AD=2.6P PS=11.04U
+ PD=11.04U
M$13 V_out V_in_n \$5 VSS nfet_03v3 L=0.5U W=10U AS=2.6P AD=2.6P PS=11.04U
+ PD=11.04U
R$17 V_out V_ref VSS 15000 ppolyf_u_1k L=45U W=3U
R$20 \$2 VDD VSS 36666.6666667 ppolyf_u_1k L=110U W=3U
M$25 VSS VSS VSS VSS nfet_03v3 L=0.5U W=3U AS=1.305P AD=1.305P PS=6.24U PD=6.24U
M$26 \$2 \$2 VSS VSS nfet_03v3 L=0.5U W=30U AS=7.8P AD=7.8P PS=40.4U PD=40.4U
M$36 \$5 \$2 VSS VSS nfet_03v3 L=0.5U W=3U AS=0.78P AD=0.78P PS=4.04U PD=4.04U
.ENDS tanh_ota

.SUBCKT voltage_reference VDD v_1_65 v_1_25 v_1_15 VSS
M$1 \$16 VDD VDD VDD pfet_03v3 L=2U W=20U AS=9.1P AD=9.1P PS=31.82U PD=31.82U
M$2 VDD \$16 \$16 VDD pfet_03v3 L=2U W=20U AS=5.2P AD=5.2P PS=21.04U PD=21.04U
M$3 \$17 \$16 VDD VDD pfet_03v3 L=2U W=20U AS=5.2P AD=5.2P PS=21.04U PD=21.04U
M$7 \$18 VDD VDD VDD pfet_03v3 L=2U W=20U AS=9.1P AD=9.1P PS=31.82U PD=31.82U
M$8 VDD \$18 \$18 VDD pfet_03v3 L=2U W=20U AS=5.2P AD=5.2P PS=21.04U PD=21.04U
M$9 \$19 \$18 VDD VDD pfet_03v3 L=2U W=20U AS=5.2P AD=5.2P PS=21.04U PD=21.04U
M$13 \$36 VDD VDD VDD pfet_03v3 L=1U W=20U AS=9.1P AD=9.1P PS=31.82U PD=31.82U
M$14 \$37 \$23 \$36 VDD pfet_03v3 L=1U W=20U AS=5.2P AD=5.2P PS=21.04U PD=21.04U
M$15 v_1_15 v_1_15 \$37 VDD pfet_03v3 L=1U W=20U AS=5.2P AD=5.2P PS=21.04U
+ PD=21.04U
M$19 \$18 VSS VSS VSS nfet_03v3 L=2U W=10U AS=4.35P AD=4.35P PS=16.74U PD=16.74U
M$20 \$11 \$14 \$18 VSS nfet_03v3 L=2U W=10U AS=2.6P AD=2.6P PS=11.04U PD=11.04U
M$21 \$19 v_1_25 \$11 VSS nfet_03v3 L=2U W=10U AS=2.6P AD=2.6P PS=11.04U
+ PD=11.04U
M$25 \$16 VSS VSS VSS nfet_03v3 L=2U W=10U AS=4.35P AD=4.35P PS=16.74U PD=16.74U
M$26 \$10 \$12 \$16 VSS nfet_03v3 L=2U W=10U AS=2.6P AD=2.6P PS=11.04U PD=11.04U
M$27 \$17 v_1_65 \$10 VSS nfet_03v3 L=2U W=10U AS=2.6P AD=2.6P PS=11.04U
+ PD=11.04U
M$31 \$37 VDD VDD VDD pfet_03v3 L=1U W=10U AS=4.55P AD=4.55P PS=16.82U PD=16.82U
M$32 VDD \$21 \$37 VDD pfet_03v3 L=1U W=20U AS=5.2P AD=5.2P PS=22.08U PD=22.08U
R$37 \$23 \$14 VSS 3333.33333333 ppolyf_u_1k L=10U W=3U
R$38 VSS \$23 VSS 38333.3333333 ppolyf_u_1k L=115U W=3U
R$43 VDD \$12 VSS 55000 ppolyf_u_1k L=165U W=3U
M$48 \$36 VSS VSS VSS nfet_03v3 L=1U W=10U AS=4.35P AD=4.35P PS=16.74U PD=16.74U
M$49 VSS \$36 \$36 VSS nfet_03v3 L=1U W=10U AS=2.6P AD=2.6P PS=11.04U PD=11.04U
M$50 v_1_15 \$36 VSS VSS nfet_03v3 L=1U W=10U AS=2.6P AD=2.6P PS=11.04U
+ PD=11.04U
M$54 \$1 VSS VSS VSS nfet_03v3 L=1U W=10U AS=4.35P AD=4.35P PS=16.74U PD=16.74U
M$55 VSS \$1 \$1 VSS nfet_03v3 L=1U W=10U AS=2.6P AD=2.6P PS=11.04U PD=11.04U
R$61 \$21 VSS VSS 50000 ppolyf_u_1k L=150U W=3U
R$63 \$1 VDD VSS 50000 ppolyf_u_1k L=150U W=3U
M$68 \$21 VDD VDD VDD pfet_03v3 L=1U W=10U AS=4.55P AD=4.55P PS=16.82U PD=16.82U
M$69 VDD \$21 \$21 VDD pfet_03v3 L=1U W=10U AS=2.6P AD=2.6P PS=11.04U PD=11.04U
R$72 VSS v_1_65 VSS 6666.66666667 ppolyf_u_1k L=20U W=3U
R$73 \$12 \$14 VSS 13333.3333333 ppolyf_u_1k L=40U W=3U
R$75 VSS v_1_25 VSS 6666.66666667 ppolyf_u_1k L=20U W=3U
M$76 VDD VSS VSS VSS nfet_03v3 L=1U W=40U AS=17.4P AD=17.4P PS=63.48U PD=63.48U
M$77 v_1_65 \$17 VDD VSS nfet_03v3 L=1U W=100U AS=26P AD=26P PS=105.2U PD=105.2U
M$89 v_1_25 \$19 VDD VSS nfet_03v3 L=1U W=100U AS=26P AD=26P PS=105.2U PD=105.2U
M$100 \$10 VSS VSS VSS nfet_03v3 L=2U W=5U AS=2.175P AD=2.175P PS=9.24U PD=9.24U
M$101 VSS \$1 \$10 VSS nfet_03v3 L=2U W=10U AS=2.6P AD=2.6P PS=12.08U PD=12.08U
M$106 \$11 VSS VSS VSS nfet_03v3 L=2U W=5U AS=2.175P AD=2.175P PS=9.24U PD=9.24U
M$107 VSS \$1 \$11 VSS nfet_03v3 L=2U W=10U AS=2.6P AD=2.6P PS=12.08U PD=12.08U
.ENDS voltage_reference

.SUBCKT gilbert_multiplier_current V_tail V_x_p V_x_n V_w_n V_w_p I_o_n I_o_p
+ VSS
M$1 I_o_n VSS VSS VSS nfet_03v3 L=0.5U W=10U AS=4.35P AD=4.35P PS=18.48U
+ PD=18.48U
M$2 \$10 V_w_p I_o_n VSS nfet_03v3 L=0.5U W=20U AS=5.2P AD=5.2P PS=24.16U
+ PD=24.16U
M$3 I_o_p V_w_n \$10 VSS nfet_03v3 L=0.5U W=20U AS=5.2P AD=5.2P PS=24.16U
+ PD=24.16U
M$12 \$23 V_w_n I_o_n VSS nfet_03v3 L=0.5U W=20U AS=5.2P AD=5.2P PS=24.16U
+ PD=24.16U
M$13 I_o_p V_w_p \$23 VSS nfet_03v3 L=0.5U W=20U AS=5.2P AD=5.2P PS=24.16U
+ PD=24.16U
M$21 I_o_p VSS VSS VSS nfet_03v3 L=0.5U W=10U AS=4.35P AD=4.35P PS=18.48U
+ PD=18.48U
M$41 \$3 VSS VSS VSS nfet_03v3 L=1U W=8U AS=3.48P AD=3.48P PS=13.74U PD=13.74U
M$42 VSS V_tail \$3 VSS nfet_03v3 L=1U W=8U AS=2.08P AD=2.08P PS=9.04U PD=9.04U
M$43 \$4 V_tail VSS VSS nfet_03v3 L=1U W=8U AS=2.08P AD=2.08P PS=9.04U PD=9.04U
M$47 \$10 VSS VSS VSS nfet_03v3 L=0.5U W=10U AS=4.35P AD=4.35P PS=16.74U
+ PD=16.74U
M$48 \$3 V_x_p \$10 VSS nfet_03v3 L=0.5U W=10U AS=2.6P AD=2.6P PS=11.04U
+ PD=11.04U
M$51 \$23 VSS VSS VSS nfet_03v3 L=0.5U W=10U AS=4.35P AD=4.35P PS=16.74U
+ PD=16.74U
M$52 \$4 V_x_n \$23 VSS nfet_03v3 L=0.5U W=10U AS=2.6P AD=2.6P PS=11.04U
+ PD=11.04U
R$55 \$3 \$4 VSS 15400 ppolyf_u_1k L=46.2U W=3U
.ENDS gilbert_multiplier_current

.SUBCKT cg_amp_tia V_ref V_out I_in VSS
M$1 V_out V_ref I_in VSS nfet_03v3 L=0.5U W=5U AS=2.175P AD=2.175P PS=9.24U
+ PD=9.24U
R$3 V_out V_ref VSS 2700 ppolyf_u_1k L=8.1U W=3U
.ENDS cg_amp_tia
